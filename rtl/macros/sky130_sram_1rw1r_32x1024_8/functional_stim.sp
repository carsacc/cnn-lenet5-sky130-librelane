* Functional test stimulus file for 10ns period

* TT process corner
.lib "/home/carlos/.ciel/sky130A/libs.tech/ngspice/sky130.lib.spice" tt
.include "/tmp/openram_carlos_1976527_temp/sram.sp"

* Global Power Supplies
Vvdd vdd 0 1.8

*Nodes gnd and 0 are the same global ground node in ngspice/hspice/xa. Otherwise, this source may be needed.
Vgnd gnd 0 0.0

* Instantiation of the SRAM
Xsky130_sram_1rw1r_32x1024_8 din0_0 din0_1 din0_2 din0_3 din0_4 din0_5 din0_6 din0_7 din0_8 din0_9 din0_10 din0_11 din0_12 din0_13 din0_14 din0_15 din0_16 din0_17 din0_18 din0_19 din0_20 din0_21 din0_22 din0_23 din0_24 din0_25 din0_26 din0_27 din0_28 din0_29 din0_30 din0_31 a0_0 a0_1 a0_2 a0_3 a0_4 a0_5 a0_6 a0_7 a0_8 a0_9 a1_0 a1_1 a1_2 a1_3 a1_4 a1_5 a1_6 a1_7 a1_8 a1_9 CSB0 CSB1 WEB0 clk0 clk1 WMASK0_0 WMASK0_1 WMASK0_2 WMASK0_3 dout0_0 dout0_1 dout0_2 dout0_3 dout0_4 dout0_5 dout0_6 dout0_7 dout0_8 dout0_9 dout0_10 dout0_11 dout0_12 dout0_13 dout0_14 dout0_15 dout0_16 dout0_17 dout0_18 dout0_19 dout0_20 dout0_21 dout0_22 dout0_23 dout0_24 dout0_25 dout0_26 dout0_27 dout0_28 dout0_29 dout0_30 dout0_31 dout1_0 dout1_1 dout1_2 dout1_3 dout1_4 dout1_5 dout1_6 dout1_7 dout1_8 dout1_9 dout1_10 dout1_11 dout1_12 dout1_13 dout1_14 dout1_15 dout1_16 dout1_17 dout1_18 dout1_19 dout1_20 dout1_21 dout1_22 dout1_23 dout1_24 dout1_25 dout1_26 dout1_27 dout1_28 dout1_29 dout1_30 dout1_31 vdd gnd sky130_sram_1rw1r_32x1024_8

* SRAM output loads
CD00 dout0_0  0 27.56f
CD01 dout0_1  0 27.56f
CD02 dout0_2  0 27.56f
CD03 dout0_3  0 27.56f
CD04 dout0_4  0 27.56f
CD05 dout0_5  0 27.56f
CD06 dout0_6  0 27.56f
CD07 dout0_7  0 27.56f
CD08 dout0_8  0 27.56f
CD09 dout0_9  0 27.56f
CD010 dout0_10  0 27.56f
CD011 dout0_11  0 27.56f
CD012 dout0_12  0 27.56f
CD013 dout0_13  0 27.56f
CD014 dout0_14  0 27.56f
CD015 dout0_15  0 27.56f
CD016 dout0_16  0 27.56f
CD017 dout0_17  0 27.56f
CD018 dout0_18  0 27.56f
CD019 dout0_19  0 27.56f
CD020 dout0_20  0 27.56f
CD021 dout0_21  0 27.56f
CD022 dout0_22  0 27.56f
CD023 dout0_23  0 27.56f
CD024 dout0_24  0 27.56f
CD025 dout0_25  0 27.56f
CD026 dout0_26  0 27.56f
CD027 dout0_27  0 27.56f
CD028 dout0_28  0 27.56f
CD029 dout0_29  0 27.56f
CD030 dout0_30  0 27.56f
CD031 dout0_31  0 27.56f
CD10 dout1_0  0 27.56f
CD11 dout1_1  0 27.56f
CD12 dout1_2  0 27.56f
CD13 dout1_3  0 27.56f
CD14 dout1_4  0 27.56f
CD15 dout1_5  0 27.56f
CD16 dout1_6  0 27.56f
CD17 dout1_7  0 27.56f
CD18 dout1_8  0 27.56f
CD19 dout1_9  0 27.56f
CD110 dout1_10  0 27.56f
CD111 dout1_11  0 27.56f
CD112 dout1_12  0 27.56f
CD113 dout1_13  0 27.56f
CD114 dout1_14  0 27.56f
CD115 dout1_15  0 27.56f
CD116 dout1_16  0 27.56f
CD117 dout1_17  0 27.56f
CD118 dout1_18  0 27.56f
CD119 dout1_19  0 27.56f
CD120 dout1_20  0 27.56f
CD121 dout1_21  0 27.56f
CD122 dout1_22  0 27.56f
CD123 dout1_23  0 27.56f
CD124 dout1_24  0 27.56f
CD125 dout1_25  0 27.56f
CD126 dout1_26  0 27.56f
CD127 dout1_27  0 27.56f
CD128 dout1_28  0 27.56f
CD129 dout1_29  0 27.56f
CD130 dout1_30  0 27.56f
CD131 dout1_31  0 27.56f

* Important signals for debug
* bl:	xsram:xbank0:bl_0_1
* br:	xsram:xbank0:br_0_1
* s_en:	xsram:s_en
* q:	xsram:xbank0:xbitcell_array:xbitcell_array:xbit_r0_c0:Q
* qbar:	xsram:xbank0:xbitcell_array:xbitcell_array:xbit_r0_c0:Q_bar

* Sequence of operations
*	Idle during cycle 0 (0ns - 10ns)
*	Writing 00000001010111010111001000101110  to  address 1111111110 (from port 0) during cycle 1 (10ns - 20ns)
*	Writing 10000010111000111010101000011101  to  address 0000000011 (from port 0) during cycle 2 (20ns - 30ns)
*	Writing 00101110110001101011001010101010  to  address 0000000011 (from port 0) during cycle 3 (30ns - 40ns)
*	Reading 00101110110001101011001010101010 from address 0000000011 (from port 0) during cycle 4 (40ns - 50ns)
*	Reading 00000001010111010111001000101110 from address 1111111110 (from port 1) during cycle 4 (40ns - 50ns)
*	Reading 00000001010111010111001000101110 from address 1111111110 (from port 0) during cycle 5 (50ns - 60ns)
*	Writing 10110101010010010101010111000100  to  address 1111111011 (from port 0) during cycle 6 (60ns - 70ns)
*	Reading 00101110110001101011001010101010 from address 0000000011 (from port 0) during cycle 7 (70ns - 80ns)
*	Reading 00000001010111010111001000101110 from address 1111111110 (from port 1) during cycle 7 (70ns - 80ns)
*	Reading 00000001010111010111001000101110 from address 1111111110 (from port 0) during cycle 8 (80ns - 90ns)
*	Writing 01110111111111011100011001110001  to  address 1111111011 (from port 0) during cycle 9 (90ns - 100ns)
*	Reading 00000001010111010111001000101110 from address 1111111110 (from port 0) during cycle 10 (100ns - 110ns)
*	Reading 00101110110001101011001010101010 from address 0000000011 (from port 1) during cycle 10 (100ns - 110ns)
*	Reading 00101110110001101011001010101010 from address 0000000011 (from port 1) during cycle 11 (110ns - 120ns)
*	Writing (partial) 11111000000010000011010010110110  to  address 1111111110 with mask bit 1001 (from port 0) during cycle 12 (120ns - 130ns)
*	Reading 00101110110001101011001010101010 from address 0000000011 (from port 0) during cycle 13 (130ns - 140ns)
*	Reading 11111000010111010111001010110110 from address 1111111110 (from port 1) during cycle 13 (130ns - 140ns)
*	Reading 01110111111111011100011001110001 from address 1111111011 (from port 0) during cycle 14 (140ns - 150ns)
*	Reading 00101110110001101011001010101010 from address 0000000011 (from port 1) during cycle 14 (140ns - 150ns)
*	Reading 01110111111111011100011001110001 from address 1111111011 (from port 1) during cycle 16 (160ns - 170ns)
*	Reading 11111000010111010111001010110110 from address 1111111110 (from port 0) during cycle 17 (170ns - 180ns)
*	Reading 01110111111111011100011001110001 from address 1111111011 (from port 1) during cycle 17 (170ns - 180ns)
*	Reading 01110111111111011100011001110001 from address 1111111011 (from port 0) during cycle 18 (180ns - 190ns)
*	Reading 11111000010111010111001010110110 from address 1111111110 (from port 0) during cycle 19 (190ns - 200ns)
*	Reading 11111000010111010111001010110110 from address 1111111110 (from port 1) during cycle 19 (190ns - 200ns)
*	Writing 11011111100111001000111010111000  to  address 0000000001 (from port 0) during cycle 20 (200ns - 210ns)
*	Reading 01110111111111011100011001110001 from address 1111111011 (from port 0) during cycle 21 (210ns - 220ns)
*	Writing 00101001001111000100111001100101  to  address 1111111110 (from port 0) during cycle 22 (220ns - 230ns)
*	Reading 01110111111111011100011001110001 from address 1111111011 (from port 1) during cycle 22 (220ns - 230ns)
*	Reading 00101110110001101011001010101010 from address 0000000011 (from port 0) during cycle 23 (230ns - 240ns)
*	Reading 00101001001111000100111001100101 from address 1111111110 (from port 1) during cycle 23 (230ns - 240ns)
*	Reading 11011111100111001000111010111000 from address 0000000001 (from port 1) during cycle 24 (240ns - 250ns)
*	Writing (partial) 01100001100111001101111100110111  to  address 1111111011 with mask bit 0110 (from port 0) during cycle 25 (250ns - 260ns)
*	Reading 11011111100111001000111010111000 from address 0000000001 (from port 1) during cycle 25 (250ns - 260ns)
*	Reading 00101001001111000100111001100101 from address 1111111110 (from port 1) during cycle 26 (260ns - 270ns)
*	Reading 00101001001111000100111001100101 from address 1111111110 (from port 0) during cycle 27 (270ns - 280ns)
*	Reading 00101110110001101011001010101010 from address 0000000011 (from port 0) during cycle 28 (280ns - 290ns)
*	Reading 00101001001111000100111001100101 from address 1111111110 (from port 1) during cycle 28 (280ns - 290ns)
*	Reading 11011111100111001000111010111000 from address 0000000001 (from port 1) during cycle 29 (290ns - 300ns)
*	Reading 01110111100111001101111101110001 from address 1111111011 (from port 0) during cycle 30 (300ns - 310ns)
*	Reading 00101001001111000100111001100101 from address 1111111110 (from port 0) during cycle 31 (310ns - 320ns)
*	Writing (partial) 01000100000111101001000110010010  to  address 1111111011 with mask bit 0001 (from port 0) during cycle 32 (320ns - 330ns)
*	Reading 11011111100111001000111010111000 from address 0000000001 (from port 1) during cycle 33 (330ns - 340ns)
*	Reading 01110111100111001101111110010010 from address 1111111011 (from port 0) during cycle 34 (340ns - 350ns)
*	Reading 01110111100111001101111110010010 from address 1111111011 (from port 1) during cycle 34 (340ns - 350ns)
*	Reading 11011111100111001000111010111000 from address 0000000001 (from port 0) during cycle 35 (350ns - 360ns)
*	Writing (partial) 01011000111000011110000010100101  to  address 0000000001 with mask bit 1000 (from port 0) during cycle 36 (360ns - 370ns)
*	Reading 01110111100111001101111110010010 from address 1111111011 (from port 0) during cycle 37 (370ns - 380ns)
*	Writing (partial) 00010000001101111010100011111000  to  address 0000000011 with mask bit 1011 (from port 0) during cycle 38 (380ns - 390ns)
*	Reading 01011000100111001000111010111000 from address 0000000001 (from port 1) during cycle 38 (380ns - 390ns)
*	Reading 01011000100111001000111010111000 from address 0000000001 (from port 0) during cycle 39 (390ns - 400ns)
*	Reading 00010000110001101010100011111000 from address 0000000011 (from port 1) during cycle 39 (390ns - 400ns)
*	Reading 01110111100111001101111110010010 from address 1111111011 (from port 1) during cycle 40 (400ns - 410ns)
*	Writing (partial) 01011111000101010100111001001111  to  address 0000000011 with mask bit 0110 (from port 0) during cycle 41 (410ns - 420ns)
*	Writing 01001100111110000101011111001110  to  address 0000000011 (from port 0) during cycle 42 (420ns - 430ns)
*	Reading 00101001001111000100111001100101 from address 1111111110 (from port 0) during cycle 43 (430ns - 440ns)
*	Reading 01001100111110000101011111001110 from address 0000000011 (from port 1) during cycle 43 (430ns - 440ns)
*	Writing (partial) 10001110111101100101000110101110  to  address 1111111011 with mask bit 0110 (from port 0) during cycle 44 (440ns - 450ns)
*	Reading 01001100111110000101011111001110 from address 0000000011 (from port 1) during cycle 44 (440ns - 450ns)
*	Reading 01011000100111001000111010111000 from address 0000000001 (from port 0) during cycle 46 (460ns - 470ns)
*	Reading 01011000100111001000111010111000 from address 0000000001 (from port 0) during cycle 47 (470ns - 480ns)
*	Reading 00101001001111000100111001100101 from address 1111111110 (from port 1) during cycle 47 (470ns - 480ns)
*	Reading 01011000100111001000111010111000 from address 0000000001 (from port 0) during cycle 48 (480ns - 490ns)
*	Writing (partial) 10010101010110001001111101000010  to  address 1111111110 with mask bit 0111 (from port 0) during cycle 49 (490ns - 500ns)
*	Reading 00101001010110001001111101000010 from address 1111111110 (from port 1) during cycle 50 (500ns - 510ns)
*	Writing 00101010011000101011100111110001  to  address 0000000001 (from port 0) during cycle 51 (510ns - 520ns)
*	Reading 00101001010110001001111101000010 from address 1111111110 (from port 1) during cycle 51 (510ns - 520ns)
*	Writing 00111101101010100000100011110110  to  address 1111111011 (from port 0) during cycle 53 (530ns - 540ns)
*	Reading 01001100111110000101011111001110 from address 0000000011 (from port 1) during cycle 53 (530ns - 540ns)
*	Writing (partial) 00100000100110111010101100001101  to  address 1111111011 with mask bit 1001 (from port 0) during cycle 54 (540ns - 550ns)
*	Writing 11101100100110111011110101101011  to  address 1111111101 (from port 0) during cycle 55 (550ns - 560ns)
*	Reading 01001100111110000101011111001110 from address 0000000011 (from port 0) during cycle 56 (560ns - 570ns)
*	Reading 01001100111110000101011111001110 from address 0000000011 (from port 1) during cycle 56 (560ns - 570ns)
*	Reading 00100000101010100000100000001101 from address 1111111011 (from port 0) during cycle 57 (570ns - 580ns)
*	Reading 00101010011000101011100111110001 from address 0000000001 (from port 1) during cycle 57 (570ns - 580ns)
*	Writing (partial) 01100101001010100101011101000101  to  address 0000000001 with mask bit 0111 (from port 0) during cycle 58 (580ns - 590ns)
*	Reading 11101100100110111011110101101011 from address 1111111101 (from port 1) during cycle 58 (580ns - 590ns)
*	Writing (partial) 11110001110111001100101101000100  to  address 0000000001 with mask bit 1001 (from port 0) during cycle 59 (590ns - 600ns)
*	Reading 11110001001010100101011101000100 from address 0000000001 (from port 0) during cycle 60 (600ns - 610ns)
*	Reading 01001100111110000101011111001110 from address 0000000011 (from port 1) during cycle 60 (600ns - 610ns)
*	Reading 11101100100110111011110101101011 from address 1111111101 (from port 0) during cycle 61 (610ns - 620ns)
*	Reading 01001100111110000101011111001110 from address 0000000011 (from port 0) during cycle 62 (620ns - 630ns)
*	Writing 10011000110101101011001000010001  to  address 0000000011 (from port 0) during cycle 63 (630ns - 640ns)
*	Reading 10011000110101101011001000010001 from address 0000000011 (from port 0) during cycle 65 (650ns - 660ns)
*	Writing (partial) 11101001000100111011010101110010  to  address 1111111101 with mask bit 1100 (from port 0) during cycle 66 (660ns - 670ns)
*	Writing (partial) 00101100100101100010000001001110  to  address 1111111101 with mask bit 1000 (from port 0) during cycle 67 (670ns - 680ns)
*	Reading 11110001001010100101011101000100 from address 0000000001 (from port 0) during cycle 68 (680ns - 690ns)
*	Reading 11110001001010100101011101000100 from address 0000000001 (from port 0) during cycle 69 (690ns - 700ns)
*	Reading 00101001010110001001111101000010 from address 1111111110 (from port 1) during cycle 69 (690ns - 700ns)
*	Writing (partial) 01000000100101011100100111110110  to  address 0000000001 with mask bit 1011 (from port 0) during cycle 70 (700ns - 710ns)
*	Writing 10000110111000100000001010111010  to  address 0000000000 (from port 0) during cycle 73 (730ns - 740ns)
*	Writing (partial) 00100101000010001011001000010110  to  address 0000000000 with mask bit 0111 (from port 0) during cycle 74 (740ns - 750ns)
*	Reading 01000000001010101100100111110110 from address 0000000001 (from port 0) during cycle 75 (750ns - 760ns)
*	Writing (partial) 11111010011110111001100000000001  to  address 0000000000 with mask bit 0001 (from port 0) during cycle 76 (760ns - 770ns)
*	Writing (partial) 00111010110011111010000101011010  to  address 0000000001 with mask bit 0101 (from port 0) during cycle 77 (770ns - 780ns)
*	Reading 00101100000100111011110101101011 from address 1111111101 (from port 1) during cycle 77 (770ns - 780ns)
*	Writing (partial) 10110101001000001001100001111001  to  address 0000000011 with mask bit 1110 (from port 0) during cycle 78 (780ns - 790ns)
*	Reading 01000000110011111100100101011010 from address 0000000001 (from port 0) during cycle 79 (790ns - 800ns)
*	Reading 10000110000010001011001000000001 from address 0000000000 (from port 1) during cycle 79 (790ns - 800ns)
*	Writing 00100100001101111101010011111001  to  address 0000000010 (from port 0) during cycle 80 (800ns - 810ns)
*	Reading 01000000110011111100100101011010 from address 0000000001 (from port 1) during cycle 80 (800ns - 810ns)
*	Reading 01000000110011111100100101011010 from address 0000000001 (from port 0) during cycle 81 (810ns - 820ns)
*	Reading 10110101001000001001100000010001 from address 0000000011 (from port 1) during cycle 81 (810ns - 820ns)
*	Reading 00100000101010100000100000001101 from address 1111111011 (from port 1) during cycle 82 (820ns - 830ns)
*	Reading 00100000101010100000100000001101 from address 1111111011 (from port 0) during cycle 83 (830ns - 840ns)
*	Reading 10000110000010001011001000000001 from address 0000000000 (from port 1) during cycle 83 (830ns - 840ns)
*	Writing (partial) 01111000101110111010110100010100  to  address 0000000001 with mask bit 0010 (from port 0) during cycle 84 (840ns - 850ns)
*	Reading 10110101001000001001100000010001 from address 0000000011 (from port 1) during cycle 84 (840ns - 850ns)
*	Reading 01000000110011111010110101011010 from address 0000000001 (from port 0) during cycle 85 (850ns - 860ns)
*	Reading 01000000110011111010110101011010 from address 0000000001 (from port 1) during cycle 85 (850ns - 860ns)
*	Reading 00100000101010100000100000001101 from address 1111111011 (from port 1) during cycle 86 (860ns - 870ns)
*	Writing (partial) 01001101000101010101011011110010  to  address 0000000010 with mask bit 1011 (from port 0) during cycle 87 (870ns - 880ns)
*	Reading 00100000101010100000100000001101 from address 1111111011 (from port 1) during cycle 87 (870ns - 880ns)
*	Reading 00100000101010100000100000001101 from address 1111111011 (from port 0) during cycle 88 (880ns - 890ns)
*	Reading 01001101001101110101011011110010 from address 0000000010 (from port 0) during cycle 89 (890ns - 900ns)
*	Reading 10110101001000001001100000010001 from address 0000000011 (from port 0) during cycle 90 (900ns - 910ns)
*	Reading 00100000101010100000100000001101 from address 1111111011 (from port 0) during cycle 91 (910ns - 920ns)
*	Reading 10110101001000001001100000010001 from address 0000000011 (from port 1) during cycle 91 (910ns - 920ns)
*	Writing 10101101000000100000100101000110  to  address 0000000001 (from port 0) during cycle 92 (920ns - 930ns)
*	Reading 10000110000010001011001000000001 from address 0000000000 (from port 0) during cycle 93 (930ns - 940ns)
*	Reading 10110101001000001001100000010001 from address 0000000011 (from port 1) during cycle 93 (930ns - 940ns)
*	Reading 00101001010110001001111101000010 from address 1111111110 (from port 0) during cycle 94 (940ns - 950ns)
*	Reading 00101100000100111011110101101011 from address 1111111101 (from port 1) during cycle 94 (940ns - 950ns)
*	Reading 10110101001000001001100000010001 from address 0000000011 (from port 0) during cycle 95 (950ns - 960ns)
*	Reading 00101100000100111011110101101011 from address 1111111101 (from port 0) during cycle 96 (960ns - 970ns)
*	Writing 01011000000010101101111010011111  to  address 0000000001 (from port 0) during cycle 97 (970ns - 980ns)
*	Writing 00000101110111000110101011010100  to  address 0000000001 (from port 0) during cycle 98 (980ns - 990ns)
*	Reading 00101100000100111011110101101011 from address 1111111101 (from port 1) during cycle 98 (980ns - 990ns)
*	Reading 00100000101010100000100000001101 from address 1111111011 (from port 1) during cycle 99 (990ns - 1000ns)
*	Writing 11101001101110111001100100000101  to  address 1111111110 (from port 0) during cycle 100 (1000ns - 1010ns)
*	Writing 00011100011100111011111001010001  to  address 1111111110 (from port 0) during cycle 102 (1020ns - 1030ns)
*	Reading 01001101001101110101011011110010 from address 0000000010 (from port 1) during cycle 104 (1040ns - 1050ns)
*	Reading 00100000101010100000100000001101 from address 1111111011 (from port 0) during cycle 105 (1050ns - 1060ns)
*	Reading 10000110000010001011001000000001 from address 0000000000 (from port 0) during cycle 106 (1060ns - 1070ns)
*	Reading 00011100011100111011111001010001 from address 1111111110 (from port 1) during cycle 106 (1060ns - 1070ns)
*	Reading 00101100000100111011110101101011 from address 1111111101 (from port 0) during cycle 107 (1070ns - 1080ns)
*	Reading 00100000101010100000100000001101 from address 1111111011 (from port 0) during cycle 108 (1080ns - 1090ns)
*	Reading 10000110000010001011001000000001 from address 0000000000 (from port 1) during cycle 108 (1080ns - 1090ns)
*	Reading 01001101001101110101011011110010 from address 0000000010 (from port 0) during cycle 109 (1090ns - 1100ns)
*	Reading 10000110000010001011001000000001 from address 0000000000 (from port 1) during cycle 110 (1100ns - 1110ns)
*	Reading 10000110000010001011001000000001 from address 0000000000 (from port 0) during cycle 111 (1110ns - 1120ns)
*	Reading 00101100000100111011110101101011 from address 1111111101 (from port 1) during cycle 111 (1110ns - 1120ns)
*	Writing 00100010111001110000100110110000  to  address 1111111011 (from port 0) during cycle 112 (1120ns - 1130ns)
*	Reading 10110101001000001001100000010001 from address 0000000011 (from port 0) during cycle 113 (1130ns - 1140ns)
*	Writing (partial) 01100011111001001011001111110010  to  address 1111111101 with mask bit 1110 (from port 0) during cycle 114 (1140ns - 1150ns)
*	Reading 10000110000010001011001000000001 from address 0000000000 (from port 0) during cycle 115 (1150ns - 1160ns)
*	Writing 01001011101111000111100110101001  to  address 1111111101 (from port 0) during cycle 116 (1160ns - 1170ns)
*	Writing 11111111000010000011111000011000  to  address 0000000010 (from port 0) during cycle 117 (1170ns - 1180ns)
*	Reading 01001011101111000111100110101001 from address 1111111101 (from port 1) during cycle 117 (1170ns - 1180ns)
*	Reading 10110101001000001001100000010001 from address 0000000011 (from port 0) during cycle 118 (1180ns - 1190ns)
*	Reading 10110101001000001001100000010001 from address 0000000011 (from port 1) during cycle 118 (1180ns - 1190ns)
*	Reading 01001011101111000111100110101001 from address 1111111101 (from port 0) during cycle 119 (1190ns - 1200ns)
*	Writing 00010100100101101110010100000011  to  address 1111111110 (from port 0) during cycle 120 (1200ns - 1210ns)
*	Reading 10000110000010001011001000000001 from address 0000000000 (from port 0) during cycle 121 (1210ns - 1220ns)
*	Reading 11111111000010000011111000011000 from address 0000000010 (from port 1) during cycle 121 (1210ns - 1220ns)
*	Writing 01001010100011010011100111100011  to  address 0000000010 (from port 0) during cycle 123 (1230ns - 1240ns)
*	Reading 10110101001000001001100000010001 from address 0000000011 (from port 1) during cycle 123 (1230ns - 1240ns)
*	Writing 00010101101100000110110011101110  to  address 1111111011 (from port 0) during cycle 124 (1240ns - 1250ns)
*	Writing (partial) 11111101110010000010111110000111  to  address 0000000011 with mask bit 1000 (from port 0) during cycle 125 (1250ns - 1260ns)
*	Writing (partial) 11011000010010000101100101000011  to  address 0000000000 with mask bit 0011 (from port 0) during cycle 126 (1260ns - 1270ns)
*	Writing (partial) 00000000011001011110111110001111  to  address 1111111011 with mask bit 0100 (from port 0) during cycle 127 (1270ns - 1280ns)
*	Reading 11111101001000001001100000010001 from address 0000000011 (from port 0) during cycle 128 (1280ns - 1290ns)
*	Reading 01001011101111000111100110101001 from address 1111111101 (from port 1) during cycle 129 (1290ns - 1300ns)
*	Reading 00000101110111000110101011010100 from address 0000000001 (from port 0) during cycle 131 (1310ns - 1320ns)
*	Reading 01001010100011010011100111100011 from address 0000000010 (from port 1) during cycle 131 (1310ns - 1320ns)
*	Writing 00110100001100011111101000101010  to  address 1111111110 (from port 0) during cycle 132 (1320ns - 1330ns)
*	Reading 11111101001000001001100000010001 from address 0000000011 (from port 1) during cycle 132 (1320ns - 1330ns)
*	Writing 00010110000001011100001010100001  to  address 0000000010 (from port 0) during cycle 133 (1330ns - 1340ns)
*	Writing 01001010101110111111001011101100  to  address 0000000001 (from port 0) during cycle 134 (1340ns - 1350ns)
*	Reading 00010110000001011100001010100001 from address 0000000010 (from port 1) during cycle 134 (1340ns - 1350ns)
*	Writing 10000010010010100000111001101001  to  address 1111111110 (from port 0) during cycle 135 (1350ns - 1360ns)
*	Reading 10000110000010000101100101000011 from address 0000000000 (from port 1) during cycle 135 (1350ns - 1360ns)
*	Writing 11010000101010101110001011000110  to  address 0000000001 (from port 0) during cycle 136 (1360ns - 1370ns)
*	Writing 11000011000111111001000110110111  to  address 0000000000 (from port 0) during cycle 137 (1370ns - 1380ns)
*	Reading 11111101001000001001100000010001 from address 0000000011 (from port 0) during cycle 138 (1380ns - 1390ns)
*	Reading 00010110000001011100001010100001 from address 0000000010 (from port 1) during cycle 138 (1380ns - 1390ns)
*	Reading 11010000101010101110001011000110 from address 0000000001 (from port 0) during cycle 139 (1390ns - 1400ns)
*	Reading 10000010010010100000111001101001 from address 1111111110 (from port 1) during cycle 141 (1410ns - 1420ns)
*	Reading 11010000101010101110001011000110 from address 0000000001 (from port 0) during cycle 142 (1420ns - 1430ns)
*	Reading 11000011000111111001000110110111 from address 0000000000 (from port 1) during cycle 142 (1420ns - 1430ns)
*	Reading 00010101011001010110110011101110 from address 1111111011 (from port 0) during cycle 143 (1430ns - 1440ns)
*	Reading 01001011101111000111100110101001 from address 1111111101 (from port 1) during cycle 143 (1430ns - 1440ns)
*	Writing (partial) 11010000001011001111100100000010  to  address 0000000001 with mask bit 1101 (from port 0) during cycle 144 (1440ns - 1450ns)
*	Reading 10000010010010100000111001101001 from address 1111111110 (from port 0) during cycle 145 (1450ns - 1460ns)
*	Reading 00010101011001010110110011101110 from address 1111111011 (from port 1) during cycle 145 (1450ns - 1460ns)
*	Writing 10001010010110100001001111000100  to  address 1111111100 (from port 0) during cycle 146 (1460ns - 1470ns)
*	Writing (partial) 01101100101111110101110010111000  to  address 0000000011 with mask bit 0110 (from port 0) during cycle 147 (1470ns - 1480ns)
*	Reading 10001010010110100001001111000100 from address 1111111100 (from port 0) during cycle 148 (1480ns - 1490ns)
*	Reading 00010101011001010110110011101110 from address 1111111011 (from port 1) during cycle 148 (1480ns - 1490ns)
*	Reading 10000010010010100000111001101001 from address 1111111110 (from port 0) during cycle 149 (1490ns - 1500ns)
*	Reading 10001010010110100001001111000100 from address 1111111100 (from port 1) during cycle 149 (1490ns - 1500ns)
*	Reading 00010101011001010110110011101110 from address 1111111011 (from port 1) during cycle 150 (1500ns - 1510ns)
*	Reading 11000011000111111001000110110111 from address 0000000000 (from port 0) during cycle 151 (1510ns - 1520ns)
*	Reading 11010000001011001110001000000010 from address 0000000001 (from port 0) during cycle 152 (1520ns - 1530ns)
*	Reading 00010101011001010110110011101110 from address 1111111011 (from port 1) during cycle 152 (1520ns - 1530ns)
*	Reading 00010101011001010110110011101110 from address 1111111011 (from port 0) during cycle 153 (1530ns - 1540ns)
*	Reading 00010101011001010110110011101110 from address 1111111011 (from port 0) during cycle 154 (1540ns - 1550ns)
*	Writing (partial) 00000101010101101000111011011001  to  address 0000000001 with mask bit 0001 (from port 0) during cycle 155 (1550ns - 1560ns)
*	Writing 11001110101101111010101001000110  to  address 0000000011 (from port 0) during cycle 156 (1560ns - 1570ns)
*	Reading 00010110000001011100001010100001 from address 0000000010 (from port 1) during cycle 156 (1560ns - 1570ns)
*	Reading 10000010010010100000111001101001 from address 1111111110 (from port 0) during cycle 157 (1570ns - 1580ns)
*	Reading 00010101011001010110110011101110 from address 1111111011 (from port 0) during cycle 158 (1580ns - 1590ns)
*	Reading 00010110000001011100001010100001 from address 0000000010 (from port 1) during cycle 158 (1580ns - 1590ns)
*	Writing 01110010011101011101110010001110  to  address 0000000010 (from port 0) during cycle 159 (1590ns - 1600ns)
*	Reading 11010000001011001110001011011001 from address 0000000001 (from port 0) during cycle 160 (1600ns - 1610ns)
*	Reading 10001010010110100001001111000100 from address 1111111100 (from port 0) during cycle 162 (1620ns - 1630ns)
*	Reading 01110010011101011101110010001110 from address 0000000010 (from port 1) during cycle 162 (1620ns - 1630ns)
*	Reading 11000011000111111001000110110111 from address 0000000000 (from port 0) during cycle 163 (1630ns - 1640ns)
*	Writing (partial) 10011001110111110010110110101001  to  address 0000000001 with mask bit 0100 (from port 0) during cycle 164 (1640ns - 1650ns)
*	Reading 11000011000111111001000110110111 from address 0000000000 (from port 1) during cycle 164 (1640ns - 1650ns)
*	Reading 00010101011001010110110011101110 from address 1111111011 (from port 0) during cycle 165 (1650ns - 1660ns)
*	Reading 01110010011101011101110010001110 from address 0000000010 (from port 1) during cycle 165 (1650ns - 1660ns)
*	Reading 11010000110111111110001011011001 from address 0000000001 (from port 0) during cycle 166 (1660ns - 1670ns)
*	Reading 01110010011101011101110010001110 from address 0000000010 (from port 1) during cycle 166 (1660ns - 1670ns)
*	Reading 10001010010110100001001111000100 from address 1111111100 (from port 0) during cycle 167 (1670ns - 1680ns)
*	Reading 10001010010110100001001111000100 from address 1111111100 (from port 0) during cycle 168 (1680ns - 1690ns)
*	Reading 01001011101111000111100110101001 from address 1111111101 (from port 1) during cycle 168 (1680ns - 1690ns)
*	Reading 01001011101111000111100110101001 from address 1111111101 (from port 0) during cycle 169 (1690ns - 1700ns)
*	Reading 00010101011001010110110011101110 from address 1111111011 (from port 1) during cycle 169 (1690ns - 1700ns)
*	Reading 11010000110111111110001011011001 from address 0000000001 (from port 1) during cycle 170 (1700ns - 1710ns)
*	Reading 10001010010110100001001111000100 from address 1111111100 (from port 0) during cycle 171 (1710ns - 1720ns)
*	Reading 11001110101101111010101001000110 from address 0000000011 (from port 1) during cycle 171 (1710ns - 1720ns)
*	Writing 10011001110000101000111100111010  to  address 0000000011 (from port 0) during cycle 172 (1720ns - 1730ns)
*	Reading 01001011101111000111100110101001 from address 1111111101 (from port 1) during cycle 173 (1730ns - 1740ns)
*	Reading 10011001110000101000111100111010 from address 0000000011 (from port 1) during cycle 174 (1740ns - 1750ns)
*	Reading 10011001110000101000111100111010 from address 0000000011 (from port 0) during cycle 175 (1750ns - 1760ns)
*	Reading 11010000110111111110001011011001 from address 0000000001 (from port 0) during cycle 176 (1760ns - 1770ns)
*	Reading 10011001110000101000111100111010 from address 0000000011 (from port 1) during cycle 176 (1760ns - 1770ns)
*	Writing 10111101010110000001111110111001  to  address 1111111101 (from port 0) during cycle 177 (1770ns - 1780ns)
*	Writing 11111000010111001110100010000000  to  address 1111111101 (from port 0) during cycle 178 (1780ns - 1790ns)
*	Writing 11101111000001110100101010101010  to  address 0000000000 (from port 0) during cycle 179 (1790ns - 1800ns)
*	Reading 01110010011101011101110010001110 from address 0000000010 (from port 1) during cycle 179 (1790ns - 1800ns)
*	Writing 01101011100110101111100001100111  to  address 1111111101 (from port 0) during cycle 180 (1800ns - 1810ns)
*	Reading 00010101011001010110110011101110 from address 1111111011 (from port 1) during cycle 180 (1800ns - 1810ns)
*	Writing (partial) 11100001010010010100110000010101  to  address 0000000000 with mask bit 0100 (from port 0) during cycle 181 (1810ns - 1820ns)
*	Reading 01101011100110101111100001100111 from address 1111111101 (from port 1) during cycle 181 (1810ns - 1820ns)
*	Reading 01110010011101011101110010001110 from address 0000000010 (from port 0) during cycle 182 (1820ns - 1830ns)
*	Reading 10011001110000101000111100111010 from address 0000000011 (from port 1) during cycle 182 (1820ns - 1830ns)
*	Reading 10001010010110100001001111000100 from address 1111111100 (from port 0) during cycle 183 (1830ns - 1840ns)
*	Reading 11101111010010010100101010101010 from address 0000000000 (from port 0) during cycle 184 (1840ns - 1850ns)
*	Reading 10000010010010100000111001101001 from address 1111111110 (from port 1) during cycle 184 (1840ns - 1850ns)
*	Reading 11101111010010010100101010101010 from address 0000000000 (from port 0) during cycle 185 (1850ns - 1860ns)
*	Reading 01101011100110101111100001100111 from address 1111111101 (from port 1) during cycle 185 (1850ns - 1860ns)
*	Reading 10011001110000101000111100111010 from address 0000000011 (from port 0) during cycle 186 (1860ns - 1870ns)
*	Reading 01110010011101011101110010001110 from address 0000000010 (from port 1) during cycle 187 (1870ns - 1880ns)
*	Writing 00010111011110011001100111011110  to  address 1111111101 (from port 0) during cycle 188 (1880ns - 1890ns)
*	Reading 11101111010010010100101010101010 from address 0000000000 (from port 1) during cycle 188 (1880ns - 1890ns)
*	Reading 11101111010010010100101010101010 from address 0000000000 (from port 0) during cycle 189 (1890ns - 1900ns)
*	Writing (partial) 01000001001100111101100001000101  to  address 1111111100 with mask bit 0010 (from port 0) during cycle 190 (1900ns - 1910ns)
*	Reading 11010000110111111110001011011001 from address 0000000001 (from port 1) during cycle 190 (1900ns - 1910ns)
*	Writing (partial) 01100010101010011010011001100100  to  address 1111111110 with mask bit 0110 (from port 0) during cycle 191 (1910ns - 1920ns)
*	Reading 11010000110111111110001011011001 from address 0000000001 (from port 1) during cycle 192 (1920ns - 1930ns)
*	Writing (partial) 10011111101100011001110000111011  to  address 1111111110 with mask bit 1000 (from port 0) during cycle 193 (1930ns - 1940ns)
*	Reading 10011001110000101000111100111010 from address 0000000011 (from port 1) during cycle 193 (1930ns - 1940ns)
*	Reading 11010000110111111110001011011001 from address 0000000001 (from port 0) during cycle 194 (1940ns - 1950ns)
*	Reading 10011001110000101000111100111010 from address 0000000011 (from port 0) during cycle 195 (1950ns - 1960ns)
*	Reading 00010111011110011001100111011110 from address 1111111101 (from port 1) during cycle 196 (1960ns - 1970ns)
*	Reading 01110010011101011101110010001110 from address 0000000010 (from port 0) during cycle 197 (1970ns - 1980ns)
*	Writing (partial) 00110001111001100011011000000100  to  address 0000000010 with mask bit 1100 (from port 0) during cycle 198 (1980ns - 1990ns)
*	Reading 00010111011110011001100111011110 from address 1111111101 (from port 1) during cycle 198 (1980ns - 1990ns)
*	Reading 10001010010110101101100011000100 from address 1111111100 (from port 0) during cycle 199 (1990ns - 2000ns)
*	Reading 00010101011001010110110011101110 from address 1111111011 (from port 0) during cycle 200 (2000ns - 2010ns)
*	Writing 10111110110011000010101010001001  to  address 1111111110 (from port 0) during cycle 201 (2010ns - 2020ns)
*	Reading 10011001110000101000111100111010 from address 0000000011 (from port 1) during cycle 201 (2010ns - 2020ns)
*	Reading 10111110110011000010101010001001 from address 1111111110 (from port 0) during cycle 202 (2020ns - 2030ns)
*	Reading 11101111010010010100101010101010 from address 0000000000 (from port 1) during cycle 202 (2020ns - 2030ns)
*	Idle during cycle 205 (2050ns - 2060ns)

* Generation of data and address signals
* (time, data): [(0, 0), (10, 0), (20, 1), (30, 0), (40, 0), (50, 0), (60, 0), (70, 0), (80, 0), (90, 1), (100, 1), (110, 1), (120, 0), (130, 0), (140, 0), (150, 0), (160, 0), (170, 0), (180, 0), (190, 0), (200, 0), (210, 0), (220, 1), (230, 1), (240, 1), (250, 1), (260, 1), (270, 1), (280, 1), (290, 1), (300, 1), (310, 1), (320, 0), (330, 0), (340, 0), (350, 0), (360, 1), (370, 1), (380, 0), (390, 0), (400, 0), (410, 1), (420, 0), (430, 0), (440, 0), (450, 0), (460, 0), (470, 0), (480, 0), (490, 0), (500, 0), (510, 1), (520, 1), (530, 0), (540, 1), (550, 1), (560, 1), (570, 1), (580, 1), (590, 0), (600, 0), (610, 0), (620, 0), (630, 1), (640, 1), (650, 1), (660, 0), (670, 0), (680, 0), (690, 0), (700, 0), (710, 0), (720, 0), (730, 0), (740, 0), (750, 0), (760, 1), (770, 0), (780, 1), (790, 1), (800, 1), (810, 1), (820, 1), (830, 1), (840, 0), (850, 0), (860, 0), (870, 0), (880, 0), (890, 0), (900, 0), (910, 0), (920, 0), (930, 0), (940, 0), (950, 0), (960, 0), (970, 1), (980, 0), (990, 0), (1000, 1), (1010, 1), (1020, 1), (1030, 1), (1040, 1), (1050, 1), (1060, 1), (1070, 1), (1080, 1), (1090, 1), (1100, 1), (1110, 1), (1120, 0), (1130, 0), (1140, 0), (1150, 0), (1160, 1), (1170, 0), (1180, 0), (1190, 0), (1200, 1), (1210, 1), (1220, 1), (1230, 1), (1240, 0), (1250, 1), (1260, 1), (1270, 1), (1280, 1), (1290, 1), (1300, 1), (1310, 1), (1320, 0), (1330, 1), (1340, 0), (1350, 1), (1360, 0), (1370, 1), (1380, 1), (1390, 1), (1400, 1), (1410, 1), (1420, 1), (1430, 1), (1440, 0), (1450, 0), (1460, 0), (1470, 0), (1480, 0), (1490, 0), (1500, 0), (1510, 0), (1520, 0), (1530, 0), (1540, 0), (1550, 1), (1560, 0), (1570, 0), (1580, 0), (1590, 0), (1600, 0), (1610, 0), (1620, 0), (1630, 0), (1640, 1), (1650, 1), (1660, 1), (1670, 1), (1680, 1), (1690, 1), (1700, 1), (1710, 1), (1720, 0), (1730, 0), (1740, 0), (1750, 0), (1760, 0), (1770, 1), (1780, 0), (1790, 0), (1800, 1), (1810, 1), (1820, 1), (1830, 1), (1840, 1), (1850, 1), (1860, 1), (1870, 1), (1880, 0), (1890, 0), (1900, 1), (1910, 0), (1920, 0), (1930, 1), (1940, 1), (1950, 1), (1960, 1), (1970, 1), (1980, 0), (1990, 0), (2000, 0), (2010, 1), (2020, 1), (2030, 1), (2040, 1), (2050, 1)]
Vdin0_0  din0_0  0 PWL (0n 0.0v 9.495n 0.0v 9.505n 0.0v 19.495n 0.0v 19.505n 1.8v 29.495n 1.8v 29.505n 0.0v 39.495n 0.0v 39.505n 0.0v 49.495n 0.0v 49.505n 0.0v 59.495n 0.0v 59.505n 0.0v 69.495n 0.0v 69.505n 0.0v 79.495n 0.0v 79.505n 0.0v 89.495n 0.0v 89.505n 1.8v 99.495n 1.8v 99.505n 1.8v 109.495n 1.8v 109.505n 1.8v 119.495n 1.8v 119.505n 0.0v 129.495n 0.0v 129.505n 0.0v 139.495n 0.0v 139.505n 0.0v 149.495n 0.0v 149.505n 0.0v 159.495n 0.0v 159.505n 0.0v 169.495n 0.0v 169.505n 0.0v 179.495n 0.0v 179.505n 0.0v 189.495n 0.0v 189.505n 0.0v 199.495n 0.0v 199.505n 0.0v 209.495n 0.0v 209.505n 0.0v 219.495n 0.0v 219.505n 1.8v 229.495n 1.8v 229.505n 1.8v 239.495n 1.8v 239.505n 1.8v 249.495n 1.8v 249.505n 1.8v 259.495n 1.8v 259.505n 1.8v 269.495n 1.8v 269.505n 1.8v 279.495n 1.8v 279.505n 1.8v 289.495n 1.8v 289.505n 1.8v 299.495n 1.8v 299.505n 1.8v 309.495n 1.8v 309.505n 1.8v 319.495n 1.8v 319.505n 0.0v 329.495n 0.0v 329.505n 0.0v 339.495n 0.0v 339.505n 0.0v 349.495n 0.0v 349.505n 0.0v 359.495n 0.0v 359.505n 1.8v 369.495n 1.8v 369.505n 1.8v 379.495n 1.8v 379.505n 0.0v 389.495n 0.0v 389.505n 0.0v 399.495n 0.0v 399.505n 0.0v 409.495n 0.0v 409.505n 1.8v 419.495n 1.8v 419.505n 0.0v 429.495n 0.0v 429.505n 0.0v 439.495n 0.0v 439.505n 0.0v 449.495n 0.0v 449.505n 0.0v 459.495n 0.0v 459.505n 0.0v 469.495n 0.0v 469.505n 0.0v 479.495n 0.0v 479.505n 0.0v 489.495n 0.0v 489.505n 0.0v 499.495n 0.0v 499.505n 0.0v 509.495n 0.0v 509.505n 1.8v 519.495n 1.8v 519.505n 1.8v 529.495n 1.8v 529.505n 0.0v 539.495n 0.0v 539.505n 1.8v 549.495n 1.8v 549.505n 1.8v 559.495n 1.8v 559.505n 1.8v 569.495n 1.8v 569.505n 1.8v 579.495n 1.8v 579.505n 1.8v 589.495n 1.8v 589.505n 0.0v 599.495n 0.0v 599.505n 0.0v 609.495n 0.0v 609.505n 0.0v 619.495n 0.0v 619.505n 0.0v 629.495n 0.0v 629.505n 1.8v 639.495n 1.8v 639.505n 1.8v 649.495n 1.8v 649.505n 1.8v 659.495n 1.8v 659.505n 0.0v 669.495n 0.0v 669.505n 0.0v 679.495n 0.0v 679.505n 0.0v 689.495n 0.0v 689.505n 0.0v 699.495n 0.0v 699.505n 0.0v 709.495n 0.0v 709.505n 0.0v 719.495n 0.0v 719.505n 0.0v 729.495n 0.0v 729.505n 0.0v 739.495n 0.0v 739.505n 0.0v 749.495n 0.0v 749.505n 0.0v 759.495n 0.0v 759.505n 1.8v 769.495n 1.8v 769.505n 0.0v 779.495n 0.0v 779.505n 1.8v 789.495n 1.8v 789.505n 1.8v 799.495n 1.8v 799.505n 1.8v 809.495n 1.8v 809.505n 1.8v 819.495n 1.8v 819.505n 1.8v 829.495n 1.8v 829.505n 1.8v 839.495n 1.8v 839.505n 0.0v 849.495n 0.0v 849.505n 0.0v 859.495n 0.0v 859.505n 0.0v 869.495n 0.0v 869.505n 0.0v 879.495n 0.0v 879.505n 0.0v 889.495n 0.0v 889.505n 0.0v 899.495n 0.0v 899.505n 0.0v 909.495n 0.0v 909.505n 0.0v 919.495n 0.0v 919.505n 0.0v 929.495n 0.0v 929.505n 0.0v 939.495n 0.0v 939.505n 0.0v 949.495n 0.0v 949.505n 0.0v 959.495n 0.0v 959.505n 0.0v 969.495n 0.0v 969.505n 1.8v 979.495n 1.8v 979.505n 0.0v 989.495n 0.0v 989.505n 0.0v 999.495n 0.0v 999.505n 1.8v 1009.495n 1.8v 1009.505n 1.8v 1019.495n 1.8v 1019.505n 1.8v 1029.495n 1.8v 1029.505n 1.8v 1039.495n 1.8v 1039.505n 1.8v 1049.495n 1.8v 1049.505n 1.8v 1059.495n 1.8v 1059.505n 1.8v 1069.495n 1.8v 1069.505n 1.8v 1079.495n 1.8v 1079.505n 1.8v 1089.495n 1.8v 1089.505n 1.8v 1099.495n 1.8v 1099.505n 1.8v 1109.495n 1.8v 1109.505n 1.8v 1119.495n 1.8v 1119.505n 0.0v 1129.495n 0.0v 1129.505n 0.0v 1139.495n 0.0v 1139.505n 0.0v 1149.495n 0.0v 1149.505n 0.0v 1159.495n 0.0v 1159.505n 1.8v 1169.495n 1.8v 1169.505n 0.0v 1179.495n 0.0v 1179.505n 0.0v 1189.495n 0.0v 1189.505n 0.0v 1199.495n 0.0v 1199.505n 1.8v 1209.495n 1.8v 1209.505n 1.8v 1219.495n 1.8v 1219.505n 1.8v 1229.495n 1.8v 1229.505n 1.8v 1239.495n 1.8v 1239.505n 0.0v 1249.495n 0.0v 1249.505n 1.8v 1259.495n 1.8v 1259.505n 1.8v 1269.495n 1.8v 1269.505n 1.8v 1279.495n 1.8v 1279.505n 1.8v 1289.495n 1.8v 1289.505n 1.8v 1299.495n 1.8v 1299.505n 1.8v 1309.495n 1.8v 1309.505n 1.8v 1319.495n 1.8v 1319.505n 0.0v 1329.495n 0.0v 1329.505n 1.8v 1339.495n 1.8v 1339.505n 0.0v 1349.495n 0.0v 1349.505n 1.8v 1359.495n 1.8v 1359.505n 0.0v 1369.495n 0.0v 1369.505n 1.8v 1379.495n 1.8v 1379.505n 1.8v 1389.495n 1.8v 1389.505n 1.8v 1399.495n 1.8v 1399.505n 1.8v 1409.495n 1.8v 1409.505n 1.8v 1419.495n 1.8v 1419.505n 1.8v 1429.495n 1.8v 1429.505n 1.8v 1439.495n 1.8v 1439.505n 0.0v 1449.495n 0.0v 1449.505n 0.0v 1459.495n 0.0v 1459.505n 0.0v 1469.495n 0.0v 1469.505n 0.0v 1479.495n 0.0v 1479.505n 0.0v 1489.495n 0.0v 1489.505n 0.0v 1499.495n 0.0v 1499.505n 0.0v 1509.495n 0.0v 1509.505n 0.0v 1519.495n 0.0v 1519.505n 0.0v 1529.495n 0.0v 1529.505n 0.0v 1539.495n 0.0v 1539.505n 0.0v 1549.495n 0.0v 1549.505n 1.8v 1559.495n 1.8v 1559.505n 0.0v 1569.495n 0.0v 1569.505n 0.0v 1579.495n 0.0v 1579.505n 0.0v 1589.495n 0.0v 1589.505n 0.0v 1599.495n 0.0v 1599.505n 0.0v 1609.495n 0.0v 1609.505n 0.0v 1619.495n 0.0v 1619.505n 0.0v 1629.495n 0.0v 1629.505n 0.0v 1639.495n 0.0v 1639.505n 1.8v 1649.495n 1.8v 1649.505n 1.8v 1659.495n 1.8v 1659.505n 1.8v 1669.495n 1.8v 1669.505n 1.8v 1679.495n 1.8v 1679.505n 1.8v 1689.495n 1.8v 1689.505n 1.8v 1699.495n 1.8v 1699.505n 1.8v 1709.495n 1.8v 1709.505n 1.8v 1719.495n 1.8v 1719.505n 0.0v 1729.495n 0.0v 1729.505n 0.0v 1739.495n 0.0v 1739.505n 0.0v 1749.495n 0.0v 1749.505n 0.0v 1759.495n 0.0v 1759.505n 0.0v 1769.495n 0.0v 1769.505n 1.8v 1779.495n 1.8v 1779.505n 0.0v 1789.495n 0.0v 1789.505n 0.0v 1799.495n 0.0v 1799.505n 1.8v 1809.495n 1.8v 1809.505n 1.8v 1819.495n 1.8v 1819.505n 1.8v 1829.495n 1.8v 1829.505n 1.8v 1839.495n 1.8v 1839.505n 1.8v 1849.495n 1.8v 1849.505n 1.8v 1859.495n 1.8v 1859.505n 1.8v 1869.495n 1.8v 1869.505n 1.8v 1879.495n 1.8v 1879.505n 0.0v 1889.495n 0.0v 1889.505n 0.0v 1899.495n 0.0v 1899.505n 1.8v 1909.495n 1.8v 1909.505n 0.0v 1919.495n 0.0v 1919.505n 0.0v 1929.495n 0.0v 1929.505n 1.8v 1939.495n 1.8v 1939.505n 1.8v 1949.495n 1.8v 1949.505n 1.8v 1959.495n 1.8v 1959.505n 1.8v 1969.495n 1.8v 1969.505n 1.8v 1979.495n 1.8v 1979.505n 0.0v 1989.495n 0.0v 1989.505n 0.0v 1999.495n 0.0v 1999.505n 0.0v 2009.495n 0.0v 2009.505n 1.8v 2019.495n 1.8v 2019.505n 1.8v 2029.495n 1.8v 2029.505n 1.8v 2039.495n 1.8v 2039.505n 1.8v 2049.495n 1.8v 2049.505n 1.8v )
* (time, data): [(0, 0), (10, 1), (20, 0), (30, 1), (40, 1), (50, 1), (60, 0), (70, 0), (80, 0), (90, 0), (100, 0), (110, 0), (120, 1), (130, 1), (140, 1), (150, 1), (160, 1), (170, 1), (180, 1), (190, 1), (200, 0), (210, 0), (220, 0), (230, 0), (240, 0), (250, 1), (260, 1), (270, 1), (280, 1), (290, 1), (300, 1), (310, 1), (320, 1), (330, 1), (340, 1), (350, 1), (360, 0), (370, 0), (380, 0), (390, 0), (400, 0), (410, 1), (420, 1), (430, 1), (440, 1), (450, 1), (460, 1), (470, 1), (480, 1), (490, 1), (500, 1), (510, 0), (520, 0), (530, 1), (540, 0), (550, 1), (560, 1), (570, 1), (580, 0), (590, 0), (600, 0), (610, 0), (620, 0), (630, 0), (640, 0), (650, 0), (660, 1), (670, 1), (680, 1), (690, 1), (700, 1), (710, 1), (720, 1), (730, 1), (740, 1), (750, 1), (760, 0), (770, 1), (780, 0), (790, 0), (800, 0), (810, 0), (820, 0), (830, 0), (840, 0), (850, 0), (860, 0), (870, 1), (880, 1), (890, 1), (900, 1), (910, 1), (920, 1), (930, 1), (940, 1), (950, 1), (960, 1), (970, 1), (980, 0), (990, 0), (1000, 0), (1010, 0), (1020, 0), (1030, 0), (1040, 0), (1050, 0), (1060, 0), (1070, 0), (1080, 0), (1090, 0), (1100, 0), (1110, 0), (1120, 0), (1130, 0), (1140, 1), (1150, 1), (1160, 0), (1170, 0), (1180, 0), (1190, 0), (1200, 1), (1210, 1), (1220, 1), (1230, 1), (1240, 1), (1250, 1), (1260, 1), (1270, 1), (1280, 1), (1290, 1), (1300, 1), (1310, 1), (1320, 1), (1330, 0), (1340, 0), (1350, 0), (1360, 1), (1370, 1), (1380, 1), (1390, 1), (1400, 1), (1410, 1), (1420, 1), (1430, 1), (1440, 1), (1450, 1), (1460, 0), (1470, 0), (1480, 0), (1490, 0), (1500, 0), (1510, 0), (1520, 0), (1530, 0), (1540, 0), (1550, 0), (1560, 1), (1570, 1), (1580, 1), (1590, 1), (1600, 1), (1610, 1), (1620, 1), (1630, 1), (1640, 0), (1650, 0), (1660, 0), (1670, 0), (1680, 0), (1690, 0), (1700, 0), (1710, 0), (1720, 1), (1730, 1), (1740, 1), (1750, 1), (1760, 1), (1770, 0), (1780, 0), (1790, 1), (1800, 1), (1810, 0), (1820, 0), (1830, 0), (1840, 0), (1850, 0), (1860, 0), (1870, 0), (1880, 1), (1890, 1), (1900, 0), (1910, 0), (1920, 0), (1930, 1), (1940, 1), (1950, 1), (1960, 1), (1970, 1), (1980, 0), (1990, 0), (2000, 0), (2010, 0), (2020, 0), (2030, 0), (2040, 0), (2050, 0)]
Vdin0_1  din0_1  0 PWL (0n 0.0v 9.495n 0.0v 9.505n 1.8v 19.495n 1.8v 19.505n 0.0v 29.495n 0.0v 29.505n 1.8v 39.495n 1.8v 39.505n 1.8v 49.495n 1.8v 49.505n 1.8v 59.495n 1.8v 59.505n 0.0v 69.495n 0.0v 69.505n 0.0v 79.495n 0.0v 79.505n 0.0v 89.495n 0.0v 89.505n 0.0v 99.495n 0.0v 99.505n 0.0v 109.495n 0.0v 109.505n 0.0v 119.495n 0.0v 119.505n 1.8v 129.495n 1.8v 129.505n 1.8v 139.495n 1.8v 139.505n 1.8v 149.495n 1.8v 149.505n 1.8v 159.495n 1.8v 159.505n 1.8v 169.495n 1.8v 169.505n 1.8v 179.495n 1.8v 179.505n 1.8v 189.495n 1.8v 189.505n 1.8v 199.495n 1.8v 199.505n 0.0v 209.495n 0.0v 209.505n 0.0v 219.495n 0.0v 219.505n 0.0v 229.495n 0.0v 229.505n 0.0v 239.495n 0.0v 239.505n 0.0v 249.495n 0.0v 249.505n 1.8v 259.495n 1.8v 259.505n 1.8v 269.495n 1.8v 269.505n 1.8v 279.495n 1.8v 279.505n 1.8v 289.495n 1.8v 289.505n 1.8v 299.495n 1.8v 299.505n 1.8v 309.495n 1.8v 309.505n 1.8v 319.495n 1.8v 319.505n 1.8v 329.495n 1.8v 329.505n 1.8v 339.495n 1.8v 339.505n 1.8v 349.495n 1.8v 349.505n 1.8v 359.495n 1.8v 359.505n 0.0v 369.495n 0.0v 369.505n 0.0v 379.495n 0.0v 379.505n 0.0v 389.495n 0.0v 389.505n 0.0v 399.495n 0.0v 399.505n 0.0v 409.495n 0.0v 409.505n 1.8v 419.495n 1.8v 419.505n 1.8v 429.495n 1.8v 429.505n 1.8v 439.495n 1.8v 439.505n 1.8v 449.495n 1.8v 449.505n 1.8v 459.495n 1.8v 459.505n 1.8v 469.495n 1.8v 469.505n 1.8v 479.495n 1.8v 479.505n 1.8v 489.495n 1.8v 489.505n 1.8v 499.495n 1.8v 499.505n 1.8v 509.495n 1.8v 509.505n 0.0v 519.495n 0.0v 519.505n 0.0v 529.495n 0.0v 529.505n 1.8v 539.495n 1.8v 539.505n 0.0v 549.495n 0.0v 549.505n 1.8v 559.495n 1.8v 559.505n 1.8v 569.495n 1.8v 569.505n 1.8v 579.495n 1.8v 579.505n 0.0v 589.495n 0.0v 589.505n 0.0v 599.495n 0.0v 599.505n 0.0v 609.495n 0.0v 609.505n 0.0v 619.495n 0.0v 619.505n 0.0v 629.495n 0.0v 629.505n 0.0v 639.495n 0.0v 639.505n 0.0v 649.495n 0.0v 649.505n 0.0v 659.495n 0.0v 659.505n 1.8v 669.495n 1.8v 669.505n 1.8v 679.495n 1.8v 679.505n 1.8v 689.495n 1.8v 689.505n 1.8v 699.495n 1.8v 699.505n 1.8v 709.495n 1.8v 709.505n 1.8v 719.495n 1.8v 719.505n 1.8v 729.495n 1.8v 729.505n 1.8v 739.495n 1.8v 739.505n 1.8v 749.495n 1.8v 749.505n 1.8v 759.495n 1.8v 759.505n 0.0v 769.495n 0.0v 769.505n 1.8v 779.495n 1.8v 779.505n 0.0v 789.495n 0.0v 789.505n 0.0v 799.495n 0.0v 799.505n 0.0v 809.495n 0.0v 809.505n 0.0v 819.495n 0.0v 819.505n 0.0v 829.495n 0.0v 829.505n 0.0v 839.495n 0.0v 839.505n 0.0v 849.495n 0.0v 849.505n 0.0v 859.495n 0.0v 859.505n 0.0v 869.495n 0.0v 869.505n 1.8v 879.495n 1.8v 879.505n 1.8v 889.495n 1.8v 889.505n 1.8v 899.495n 1.8v 899.505n 1.8v 909.495n 1.8v 909.505n 1.8v 919.495n 1.8v 919.505n 1.8v 929.495n 1.8v 929.505n 1.8v 939.495n 1.8v 939.505n 1.8v 949.495n 1.8v 949.505n 1.8v 959.495n 1.8v 959.505n 1.8v 969.495n 1.8v 969.505n 1.8v 979.495n 1.8v 979.505n 0.0v 989.495n 0.0v 989.505n 0.0v 999.495n 0.0v 999.505n 0.0v 1009.495n 0.0v 1009.505n 0.0v 1019.495n 0.0v 1019.505n 0.0v 1029.495n 0.0v 1029.505n 0.0v 1039.495n 0.0v 1039.505n 0.0v 1049.495n 0.0v 1049.505n 0.0v 1059.495n 0.0v 1059.505n 0.0v 1069.495n 0.0v 1069.505n 0.0v 1079.495n 0.0v 1079.505n 0.0v 1089.495n 0.0v 1089.505n 0.0v 1099.495n 0.0v 1099.505n 0.0v 1109.495n 0.0v 1109.505n 0.0v 1119.495n 0.0v 1119.505n 0.0v 1129.495n 0.0v 1129.505n 0.0v 1139.495n 0.0v 1139.505n 1.8v 1149.495n 1.8v 1149.505n 1.8v 1159.495n 1.8v 1159.505n 0.0v 1169.495n 0.0v 1169.505n 0.0v 1179.495n 0.0v 1179.505n 0.0v 1189.495n 0.0v 1189.505n 0.0v 1199.495n 0.0v 1199.505n 1.8v 1209.495n 1.8v 1209.505n 1.8v 1219.495n 1.8v 1219.505n 1.8v 1229.495n 1.8v 1229.505n 1.8v 1239.495n 1.8v 1239.505n 1.8v 1249.495n 1.8v 1249.505n 1.8v 1259.495n 1.8v 1259.505n 1.8v 1269.495n 1.8v 1269.505n 1.8v 1279.495n 1.8v 1279.505n 1.8v 1289.495n 1.8v 1289.505n 1.8v 1299.495n 1.8v 1299.505n 1.8v 1309.495n 1.8v 1309.505n 1.8v 1319.495n 1.8v 1319.505n 1.8v 1329.495n 1.8v 1329.505n 0.0v 1339.495n 0.0v 1339.505n 0.0v 1349.495n 0.0v 1349.505n 0.0v 1359.495n 0.0v 1359.505n 1.8v 1369.495n 1.8v 1369.505n 1.8v 1379.495n 1.8v 1379.505n 1.8v 1389.495n 1.8v 1389.505n 1.8v 1399.495n 1.8v 1399.505n 1.8v 1409.495n 1.8v 1409.505n 1.8v 1419.495n 1.8v 1419.505n 1.8v 1429.495n 1.8v 1429.505n 1.8v 1439.495n 1.8v 1439.505n 1.8v 1449.495n 1.8v 1449.505n 1.8v 1459.495n 1.8v 1459.505n 0.0v 1469.495n 0.0v 1469.505n 0.0v 1479.495n 0.0v 1479.505n 0.0v 1489.495n 0.0v 1489.505n 0.0v 1499.495n 0.0v 1499.505n 0.0v 1509.495n 0.0v 1509.505n 0.0v 1519.495n 0.0v 1519.505n 0.0v 1529.495n 0.0v 1529.505n 0.0v 1539.495n 0.0v 1539.505n 0.0v 1549.495n 0.0v 1549.505n 0.0v 1559.495n 0.0v 1559.505n 1.8v 1569.495n 1.8v 1569.505n 1.8v 1579.495n 1.8v 1579.505n 1.8v 1589.495n 1.8v 1589.505n 1.8v 1599.495n 1.8v 1599.505n 1.8v 1609.495n 1.8v 1609.505n 1.8v 1619.495n 1.8v 1619.505n 1.8v 1629.495n 1.8v 1629.505n 1.8v 1639.495n 1.8v 1639.505n 0.0v 1649.495n 0.0v 1649.505n 0.0v 1659.495n 0.0v 1659.505n 0.0v 1669.495n 0.0v 1669.505n 0.0v 1679.495n 0.0v 1679.505n 0.0v 1689.495n 0.0v 1689.505n 0.0v 1699.495n 0.0v 1699.505n 0.0v 1709.495n 0.0v 1709.505n 0.0v 1719.495n 0.0v 1719.505n 1.8v 1729.495n 1.8v 1729.505n 1.8v 1739.495n 1.8v 1739.505n 1.8v 1749.495n 1.8v 1749.505n 1.8v 1759.495n 1.8v 1759.505n 1.8v 1769.495n 1.8v 1769.505n 0.0v 1779.495n 0.0v 1779.505n 0.0v 1789.495n 0.0v 1789.505n 1.8v 1799.495n 1.8v 1799.505n 1.8v 1809.495n 1.8v 1809.505n 0.0v 1819.495n 0.0v 1819.505n 0.0v 1829.495n 0.0v 1829.505n 0.0v 1839.495n 0.0v 1839.505n 0.0v 1849.495n 0.0v 1849.505n 0.0v 1859.495n 0.0v 1859.505n 0.0v 1869.495n 0.0v 1869.505n 0.0v 1879.495n 0.0v 1879.505n 1.8v 1889.495n 1.8v 1889.505n 1.8v 1899.495n 1.8v 1899.505n 0.0v 1909.495n 0.0v 1909.505n 0.0v 1919.495n 0.0v 1919.505n 0.0v 1929.495n 0.0v 1929.505n 1.8v 1939.495n 1.8v 1939.505n 1.8v 1949.495n 1.8v 1949.505n 1.8v 1959.495n 1.8v 1959.505n 1.8v 1969.495n 1.8v 1969.505n 1.8v 1979.495n 1.8v 1979.505n 0.0v 1989.495n 0.0v 1989.505n 0.0v 1999.495n 0.0v 1999.505n 0.0v 2009.495n 0.0v 2009.505n 0.0v 2019.495n 0.0v 2019.505n 0.0v 2029.495n 0.0v 2029.505n 0.0v 2039.495n 0.0v 2039.505n 0.0v 2049.495n 0.0v 2049.505n 0.0v )
* (time, data): [(0, 0), (10, 1), (20, 1), (30, 0), (40, 0), (50, 0), (60, 1), (70, 1), (80, 1), (90, 0), (100, 0), (110, 0), (120, 1), (130, 1), (140, 1), (150, 1), (160, 1), (170, 1), (180, 1), (190, 1), (200, 0), (210, 0), (220, 1), (230, 1), (240, 1), (250, 1), (260, 1), (270, 1), (280, 1), (290, 1), (300, 1), (310, 1), (320, 0), (330, 0), (340, 0), (350, 0), (360, 1), (370, 1), (380, 0), (390, 0), (400, 0), (410, 1), (420, 1), (430, 1), (440, 1), (450, 1), (460, 1), (470, 1), (480, 1), (490, 0), (500, 0), (510, 0), (520, 0), (530, 1), (540, 1), (550, 0), (560, 0), (570, 0), (580, 1), (590, 1), (600, 1), (610, 1), (620, 1), (630, 0), (640, 0), (650, 0), (660, 0), (670, 1), (680, 1), (690, 1), (700, 1), (710, 1), (720, 1), (730, 0), (740, 1), (750, 1), (760, 0), (770, 0), (780, 0), (790, 0), (800, 0), (810, 0), (820, 0), (830, 0), (840, 1), (850, 1), (860, 1), (870, 0), (880, 0), (890, 0), (900, 0), (910, 0), (920, 1), (930, 1), (940, 1), (950, 1), (960, 1), (970, 1), (980, 1), (990, 1), (1000, 1), (1010, 1), (1020, 0), (1030, 0), (1040, 0), (1050, 0), (1060, 0), (1070, 0), (1080, 0), (1090, 0), (1100, 0), (1110, 0), (1120, 0), (1130, 0), (1140, 0), (1150, 0), (1160, 0), (1170, 0), (1180, 0), (1190, 0), (1200, 0), (1210, 0), (1220, 0), (1230, 0), (1240, 1), (1250, 1), (1260, 0), (1270, 1), (1280, 1), (1290, 1), (1300, 1), (1310, 1), (1320, 0), (1330, 0), (1340, 1), (1350, 0), (1360, 1), (1370, 1), (1380, 1), (1390, 1), (1400, 1), (1410, 1), (1420, 1), (1430, 1), (1440, 0), (1450, 0), (1460, 1), (1470, 0), (1480, 0), (1490, 0), (1500, 0), (1510, 0), (1520, 0), (1530, 0), (1540, 0), (1550, 0), (1560, 1), (1570, 1), (1580, 1), (1590, 1), (1600, 1), (1610, 1), (1620, 1), (1630, 1), (1640, 0), (1650, 0), (1660, 0), (1670, 0), (1680, 0), (1690, 0), (1700, 0), (1710, 0), (1720, 0), (1730, 0), (1740, 0), (1750, 0), (1760, 0), (1770, 0), (1780, 0), (1790, 0), (1800, 1), (1810, 1), (1820, 1), (1830, 1), (1840, 1), (1850, 1), (1860, 1), (1870, 1), (1880, 1), (1890, 1), (1900, 1), (1910, 1), (1920, 1), (1930, 0), (1940, 0), (1950, 0), (1960, 0), (1970, 0), (1980, 1), (1990, 1), (2000, 1), (2010, 0), (2020, 0), (2030, 0), (2040, 0), (2050, 0)]
Vdin0_2  din0_2  0 PWL (0n 0.0v 9.495n 0.0v 9.505n 1.8v 19.495n 1.8v 19.505n 1.8v 29.495n 1.8v 29.505n 0.0v 39.495n 0.0v 39.505n 0.0v 49.495n 0.0v 49.505n 0.0v 59.495n 0.0v 59.505n 1.8v 69.495n 1.8v 69.505n 1.8v 79.495n 1.8v 79.505n 1.8v 89.495n 1.8v 89.505n 0.0v 99.495n 0.0v 99.505n 0.0v 109.495n 0.0v 109.505n 0.0v 119.495n 0.0v 119.505n 1.8v 129.495n 1.8v 129.505n 1.8v 139.495n 1.8v 139.505n 1.8v 149.495n 1.8v 149.505n 1.8v 159.495n 1.8v 159.505n 1.8v 169.495n 1.8v 169.505n 1.8v 179.495n 1.8v 179.505n 1.8v 189.495n 1.8v 189.505n 1.8v 199.495n 1.8v 199.505n 0.0v 209.495n 0.0v 209.505n 0.0v 219.495n 0.0v 219.505n 1.8v 229.495n 1.8v 229.505n 1.8v 239.495n 1.8v 239.505n 1.8v 249.495n 1.8v 249.505n 1.8v 259.495n 1.8v 259.505n 1.8v 269.495n 1.8v 269.505n 1.8v 279.495n 1.8v 279.505n 1.8v 289.495n 1.8v 289.505n 1.8v 299.495n 1.8v 299.505n 1.8v 309.495n 1.8v 309.505n 1.8v 319.495n 1.8v 319.505n 0.0v 329.495n 0.0v 329.505n 0.0v 339.495n 0.0v 339.505n 0.0v 349.495n 0.0v 349.505n 0.0v 359.495n 0.0v 359.505n 1.8v 369.495n 1.8v 369.505n 1.8v 379.495n 1.8v 379.505n 0.0v 389.495n 0.0v 389.505n 0.0v 399.495n 0.0v 399.505n 0.0v 409.495n 0.0v 409.505n 1.8v 419.495n 1.8v 419.505n 1.8v 429.495n 1.8v 429.505n 1.8v 439.495n 1.8v 439.505n 1.8v 449.495n 1.8v 449.505n 1.8v 459.495n 1.8v 459.505n 1.8v 469.495n 1.8v 469.505n 1.8v 479.495n 1.8v 479.505n 1.8v 489.495n 1.8v 489.505n 0.0v 499.495n 0.0v 499.505n 0.0v 509.495n 0.0v 509.505n 0.0v 519.495n 0.0v 519.505n 0.0v 529.495n 0.0v 529.505n 1.8v 539.495n 1.8v 539.505n 1.8v 549.495n 1.8v 549.505n 0.0v 559.495n 0.0v 559.505n 0.0v 569.495n 0.0v 569.505n 0.0v 579.495n 0.0v 579.505n 1.8v 589.495n 1.8v 589.505n 1.8v 599.495n 1.8v 599.505n 1.8v 609.495n 1.8v 609.505n 1.8v 619.495n 1.8v 619.505n 1.8v 629.495n 1.8v 629.505n 0.0v 639.495n 0.0v 639.505n 0.0v 649.495n 0.0v 649.505n 0.0v 659.495n 0.0v 659.505n 0.0v 669.495n 0.0v 669.505n 1.8v 679.495n 1.8v 679.505n 1.8v 689.495n 1.8v 689.505n 1.8v 699.495n 1.8v 699.505n 1.8v 709.495n 1.8v 709.505n 1.8v 719.495n 1.8v 719.505n 1.8v 729.495n 1.8v 729.505n 0.0v 739.495n 0.0v 739.505n 1.8v 749.495n 1.8v 749.505n 1.8v 759.495n 1.8v 759.505n 0.0v 769.495n 0.0v 769.505n 0.0v 779.495n 0.0v 779.505n 0.0v 789.495n 0.0v 789.505n 0.0v 799.495n 0.0v 799.505n 0.0v 809.495n 0.0v 809.505n 0.0v 819.495n 0.0v 819.505n 0.0v 829.495n 0.0v 829.505n 0.0v 839.495n 0.0v 839.505n 1.8v 849.495n 1.8v 849.505n 1.8v 859.495n 1.8v 859.505n 1.8v 869.495n 1.8v 869.505n 0.0v 879.495n 0.0v 879.505n 0.0v 889.495n 0.0v 889.505n 0.0v 899.495n 0.0v 899.505n 0.0v 909.495n 0.0v 909.505n 0.0v 919.495n 0.0v 919.505n 1.8v 929.495n 1.8v 929.505n 1.8v 939.495n 1.8v 939.505n 1.8v 949.495n 1.8v 949.505n 1.8v 959.495n 1.8v 959.505n 1.8v 969.495n 1.8v 969.505n 1.8v 979.495n 1.8v 979.505n 1.8v 989.495n 1.8v 989.505n 1.8v 999.495n 1.8v 999.505n 1.8v 1009.495n 1.8v 1009.505n 1.8v 1019.495n 1.8v 1019.505n 0.0v 1029.495n 0.0v 1029.505n 0.0v 1039.495n 0.0v 1039.505n 0.0v 1049.495n 0.0v 1049.505n 0.0v 1059.495n 0.0v 1059.505n 0.0v 1069.495n 0.0v 1069.505n 0.0v 1079.495n 0.0v 1079.505n 0.0v 1089.495n 0.0v 1089.505n 0.0v 1099.495n 0.0v 1099.505n 0.0v 1109.495n 0.0v 1109.505n 0.0v 1119.495n 0.0v 1119.505n 0.0v 1129.495n 0.0v 1129.505n 0.0v 1139.495n 0.0v 1139.505n 0.0v 1149.495n 0.0v 1149.505n 0.0v 1159.495n 0.0v 1159.505n 0.0v 1169.495n 0.0v 1169.505n 0.0v 1179.495n 0.0v 1179.505n 0.0v 1189.495n 0.0v 1189.505n 0.0v 1199.495n 0.0v 1199.505n 0.0v 1209.495n 0.0v 1209.505n 0.0v 1219.495n 0.0v 1219.505n 0.0v 1229.495n 0.0v 1229.505n 0.0v 1239.495n 0.0v 1239.505n 1.8v 1249.495n 1.8v 1249.505n 1.8v 1259.495n 1.8v 1259.505n 0.0v 1269.495n 0.0v 1269.505n 1.8v 1279.495n 1.8v 1279.505n 1.8v 1289.495n 1.8v 1289.505n 1.8v 1299.495n 1.8v 1299.505n 1.8v 1309.495n 1.8v 1309.505n 1.8v 1319.495n 1.8v 1319.505n 0.0v 1329.495n 0.0v 1329.505n 0.0v 1339.495n 0.0v 1339.505n 1.8v 1349.495n 1.8v 1349.505n 0.0v 1359.495n 0.0v 1359.505n 1.8v 1369.495n 1.8v 1369.505n 1.8v 1379.495n 1.8v 1379.505n 1.8v 1389.495n 1.8v 1389.505n 1.8v 1399.495n 1.8v 1399.505n 1.8v 1409.495n 1.8v 1409.505n 1.8v 1419.495n 1.8v 1419.505n 1.8v 1429.495n 1.8v 1429.505n 1.8v 1439.495n 1.8v 1439.505n 0.0v 1449.495n 0.0v 1449.505n 0.0v 1459.495n 0.0v 1459.505n 1.8v 1469.495n 1.8v 1469.505n 0.0v 1479.495n 0.0v 1479.505n 0.0v 1489.495n 0.0v 1489.505n 0.0v 1499.495n 0.0v 1499.505n 0.0v 1509.495n 0.0v 1509.505n 0.0v 1519.495n 0.0v 1519.505n 0.0v 1529.495n 0.0v 1529.505n 0.0v 1539.495n 0.0v 1539.505n 0.0v 1549.495n 0.0v 1549.505n 0.0v 1559.495n 0.0v 1559.505n 1.8v 1569.495n 1.8v 1569.505n 1.8v 1579.495n 1.8v 1579.505n 1.8v 1589.495n 1.8v 1589.505n 1.8v 1599.495n 1.8v 1599.505n 1.8v 1609.495n 1.8v 1609.505n 1.8v 1619.495n 1.8v 1619.505n 1.8v 1629.495n 1.8v 1629.505n 1.8v 1639.495n 1.8v 1639.505n 0.0v 1649.495n 0.0v 1649.505n 0.0v 1659.495n 0.0v 1659.505n 0.0v 1669.495n 0.0v 1669.505n 0.0v 1679.495n 0.0v 1679.505n 0.0v 1689.495n 0.0v 1689.505n 0.0v 1699.495n 0.0v 1699.505n 0.0v 1709.495n 0.0v 1709.505n 0.0v 1719.495n 0.0v 1719.505n 0.0v 1729.495n 0.0v 1729.505n 0.0v 1739.495n 0.0v 1739.505n 0.0v 1749.495n 0.0v 1749.505n 0.0v 1759.495n 0.0v 1759.505n 0.0v 1769.495n 0.0v 1769.505n 0.0v 1779.495n 0.0v 1779.505n 0.0v 1789.495n 0.0v 1789.505n 0.0v 1799.495n 0.0v 1799.505n 1.8v 1809.495n 1.8v 1809.505n 1.8v 1819.495n 1.8v 1819.505n 1.8v 1829.495n 1.8v 1829.505n 1.8v 1839.495n 1.8v 1839.505n 1.8v 1849.495n 1.8v 1849.505n 1.8v 1859.495n 1.8v 1859.505n 1.8v 1869.495n 1.8v 1869.505n 1.8v 1879.495n 1.8v 1879.505n 1.8v 1889.495n 1.8v 1889.505n 1.8v 1899.495n 1.8v 1899.505n 1.8v 1909.495n 1.8v 1909.505n 1.8v 1919.495n 1.8v 1919.505n 1.8v 1929.495n 1.8v 1929.505n 0.0v 1939.495n 0.0v 1939.505n 0.0v 1949.495n 0.0v 1949.505n 0.0v 1959.495n 0.0v 1959.505n 0.0v 1969.495n 0.0v 1969.505n 0.0v 1979.495n 0.0v 1979.505n 1.8v 1989.495n 1.8v 1989.505n 1.8v 1999.495n 1.8v 1999.505n 1.8v 2009.495n 1.8v 2009.505n 0.0v 2019.495n 0.0v 2019.505n 0.0v 2029.495n 0.0v 2029.505n 0.0v 2039.495n 0.0v 2039.505n 0.0v 2049.495n 0.0v 2049.505n 0.0v )
* (time, data): [(0, 0), (10, 1), (20, 1), (30, 1), (40, 1), (50, 1), (60, 0), (70, 0), (80, 0), (90, 0), (100, 0), (110, 0), (120, 0), (130, 0), (140, 0), (150, 0), (160, 0), (170, 0), (180, 0), (190, 0), (200, 1), (210, 1), (220, 0), (230, 0), (240, 0), (250, 0), (260, 0), (270, 0), (280, 0), (290, 0), (300, 0), (310, 0), (320, 0), (330, 0), (340, 0), (350, 0), (360, 0), (370, 0), (380, 1), (390, 1), (400, 1), (410, 1), (420, 1), (430, 1), (440, 1), (450, 1), (460, 1), (470, 1), (480, 1), (490, 0), (500, 0), (510, 0), (520, 0), (530, 0), (540, 1), (550, 1), (560, 1), (570, 1), (580, 0), (590, 0), (600, 0), (610, 0), (620, 0), (630, 0), (640, 0), (650, 0), (660, 0), (670, 1), (680, 1), (690, 1), (700, 0), (710, 0), (720, 0), (730, 1), (740, 0), (750, 0), (760, 0), (770, 1), (780, 1), (790, 1), (800, 1), (810, 1), (820, 1), (830, 1), (840, 0), (850, 0), (860, 0), (870, 0), (880, 0), (890, 0), (900, 0), (910, 0), (920, 0), (930, 0), (940, 0), (950, 0), (960, 0), (970, 1), (980, 0), (990, 0), (1000, 0), (1010, 0), (1020, 0), (1030, 0), (1040, 0), (1050, 0), (1060, 0), (1070, 0), (1080, 0), (1090, 0), (1100, 0), (1110, 0), (1120, 0), (1130, 0), (1140, 0), (1150, 0), (1160, 1), (1170, 1), (1180, 1), (1190, 1), (1200, 0), (1210, 0), (1220, 0), (1230, 0), (1240, 1), (1250, 0), (1260, 0), (1270, 1), (1280, 1), (1290, 1), (1300, 1), (1310, 1), (1320, 1), (1330, 0), (1340, 1), (1350, 1), (1360, 0), (1370, 0), (1380, 0), (1390, 0), (1400, 0), (1410, 0), (1420, 0), (1430, 0), (1440, 0), (1450, 0), (1460, 0), (1470, 1), (1480, 1), (1490, 1), (1500, 1), (1510, 1), (1520, 1), (1530, 1), (1540, 1), (1550, 1), (1560, 0), (1570, 0), (1580, 0), (1590, 1), (1600, 1), (1610, 1), (1620, 1), (1630, 1), (1640, 1), (1650, 1), (1660, 1), (1670, 1), (1680, 1), (1690, 1), (1700, 1), (1710, 1), (1720, 1), (1730, 1), (1740, 1), (1750, 1), (1760, 1), (1770, 1), (1780, 0), (1790, 1), (1800, 0), (1810, 0), (1820, 0), (1830, 0), (1840, 0), (1850, 0), (1860, 0), (1870, 0), (1880, 1), (1890, 1), (1900, 0), (1910, 0), (1920, 0), (1930, 1), (1940, 1), (1950, 1), (1960, 1), (1970, 1), (1980, 0), (1990, 0), (2000, 0), (2010, 1), (2020, 1), (2030, 1), (2040, 1), (2050, 1)]
Vdin0_3  din0_3  0 PWL (0n 0.0v 9.495n 0.0v 9.505n 1.8v 19.495n 1.8v 19.505n 1.8v 29.495n 1.8v 29.505n 1.8v 39.495n 1.8v 39.505n 1.8v 49.495n 1.8v 49.505n 1.8v 59.495n 1.8v 59.505n 0.0v 69.495n 0.0v 69.505n 0.0v 79.495n 0.0v 79.505n 0.0v 89.495n 0.0v 89.505n 0.0v 99.495n 0.0v 99.505n 0.0v 109.495n 0.0v 109.505n 0.0v 119.495n 0.0v 119.505n 0.0v 129.495n 0.0v 129.505n 0.0v 139.495n 0.0v 139.505n 0.0v 149.495n 0.0v 149.505n 0.0v 159.495n 0.0v 159.505n 0.0v 169.495n 0.0v 169.505n 0.0v 179.495n 0.0v 179.505n 0.0v 189.495n 0.0v 189.505n 0.0v 199.495n 0.0v 199.505n 1.8v 209.495n 1.8v 209.505n 1.8v 219.495n 1.8v 219.505n 0.0v 229.495n 0.0v 229.505n 0.0v 239.495n 0.0v 239.505n 0.0v 249.495n 0.0v 249.505n 0.0v 259.495n 0.0v 259.505n 0.0v 269.495n 0.0v 269.505n 0.0v 279.495n 0.0v 279.505n 0.0v 289.495n 0.0v 289.505n 0.0v 299.495n 0.0v 299.505n 0.0v 309.495n 0.0v 309.505n 0.0v 319.495n 0.0v 319.505n 0.0v 329.495n 0.0v 329.505n 0.0v 339.495n 0.0v 339.505n 0.0v 349.495n 0.0v 349.505n 0.0v 359.495n 0.0v 359.505n 0.0v 369.495n 0.0v 369.505n 0.0v 379.495n 0.0v 379.505n 1.8v 389.495n 1.8v 389.505n 1.8v 399.495n 1.8v 399.505n 1.8v 409.495n 1.8v 409.505n 1.8v 419.495n 1.8v 419.505n 1.8v 429.495n 1.8v 429.505n 1.8v 439.495n 1.8v 439.505n 1.8v 449.495n 1.8v 449.505n 1.8v 459.495n 1.8v 459.505n 1.8v 469.495n 1.8v 469.505n 1.8v 479.495n 1.8v 479.505n 1.8v 489.495n 1.8v 489.505n 0.0v 499.495n 0.0v 499.505n 0.0v 509.495n 0.0v 509.505n 0.0v 519.495n 0.0v 519.505n 0.0v 529.495n 0.0v 529.505n 0.0v 539.495n 0.0v 539.505n 1.8v 549.495n 1.8v 549.505n 1.8v 559.495n 1.8v 559.505n 1.8v 569.495n 1.8v 569.505n 1.8v 579.495n 1.8v 579.505n 0.0v 589.495n 0.0v 589.505n 0.0v 599.495n 0.0v 599.505n 0.0v 609.495n 0.0v 609.505n 0.0v 619.495n 0.0v 619.505n 0.0v 629.495n 0.0v 629.505n 0.0v 639.495n 0.0v 639.505n 0.0v 649.495n 0.0v 649.505n 0.0v 659.495n 0.0v 659.505n 0.0v 669.495n 0.0v 669.505n 1.8v 679.495n 1.8v 679.505n 1.8v 689.495n 1.8v 689.505n 1.8v 699.495n 1.8v 699.505n 0.0v 709.495n 0.0v 709.505n 0.0v 719.495n 0.0v 719.505n 0.0v 729.495n 0.0v 729.505n 1.8v 739.495n 1.8v 739.505n 0.0v 749.495n 0.0v 749.505n 0.0v 759.495n 0.0v 759.505n 0.0v 769.495n 0.0v 769.505n 1.8v 779.495n 1.8v 779.505n 1.8v 789.495n 1.8v 789.505n 1.8v 799.495n 1.8v 799.505n 1.8v 809.495n 1.8v 809.505n 1.8v 819.495n 1.8v 819.505n 1.8v 829.495n 1.8v 829.505n 1.8v 839.495n 1.8v 839.505n 0.0v 849.495n 0.0v 849.505n 0.0v 859.495n 0.0v 859.505n 0.0v 869.495n 0.0v 869.505n 0.0v 879.495n 0.0v 879.505n 0.0v 889.495n 0.0v 889.505n 0.0v 899.495n 0.0v 899.505n 0.0v 909.495n 0.0v 909.505n 0.0v 919.495n 0.0v 919.505n 0.0v 929.495n 0.0v 929.505n 0.0v 939.495n 0.0v 939.505n 0.0v 949.495n 0.0v 949.505n 0.0v 959.495n 0.0v 959.505n 0.0v 969.495n 0.0v 969.505n 1.8v 979.495n 1.8v 979.505n 0.0v 989.495n 0.0v 989.505n 0.0v 999.495n 0.0v 999.505n 0.0v 1009.495n 0.0v 1009.505n 0.0v 1019.495n 0.0v 1019.505n 0.0v 1029.495n 0.0v 1029.505n 0.0v 1039.495n 0.0v 1039.505n 0.0v 1049.495n 0.0v 1049.505n 0.0v 1059.495n 0.0v 1059.505n 0.0v 1069.495n 0.0v 1069.505n 0.0v 1079.495n 0.0v 1079.505n 0.0v 1089.495n 0.0v 1089.505n 0.0v 1099.495n 0.0v 1099.505n 0.0v 1109.495n 0.0v 1109.505n 0.0v 1119.495n 0.0v 1119.505n 0.0v 1129.495n 0.0v 1129.505n 0.0v 1139.495n 0.0v 1139.505n 0.0v 1149.495n 0.0v 1149.505n 0.0v 1159.495n 0.0v 1159.505n 1.8v 1169.495n 1.8v 1169.505n 1.8v 1179.495n 1.8v 1179.505n 1.8v 1189.495n 1.8v 1189.505n 1.8v 1199.495n 1.8v 1199.505n 0.0v 1209.495n 0.0v 1209.505n 0.0v 1219.495n 0.0v 1219.505n 0.0v 1229.495n 0.0v 1229.505n 0.0v 1239.495n 0.0v 1239.505n 1.8v 1249.495n 1.8v 1249.505n 0.0v 1259.495n 0.0v 1259.505n 0.0v 1269.495n 0.0v 1269.505n 1.8v 1279.495n 1.8v 1279.505n 1.8v 1289.495n 1.8v 1289.505n 1.8v 1299.495n 1.8v 1299.505n 1.8v 1309.495n 1.8v 1309.505n 1.8v 1319.495n 1.8v 1319.505n 1.8v 1329.495n 1.8v 1329.505n 0.0v 1339.495n 0.0v 1339.505n 1.8v 1349.495n 1.8v 1349.505n 1.8v 1359.495n 1.8v 1359.505n 0.0v 1369.495n 0.0v 1369.505n 0.0v 1379.495n 0.0v 1379.505n 0.0v 1389.495n 0.0v 1389.505n 0.0v 1399.495n 0.0v 1399.505n 0.0v 1409.495n 0.0v 1409.505n 0.0v 1419.495n 0.0v 1419.505n 0.0v 1429.495n 0.0v 1429.505n 0.0v 1439.495n 0.0v 1439.505n 0.0v 1449.495n 0.0v 1449.505n 0.0v 1459.495n 0.0v 1459.505n 0.0v 1469.495n 0.0v 1469.505n 1.8v 1479.495n 1.8v 1479.505n 1.8v 1489.495n 1.8v 1489.505n 1.8v 1499.495n 1.8v 1499.505n 1.8v 1509.495n 1.8v 1509.505n 1.8v 1519.495n 1.8v 1519.505n 1.8v 1529.495n 1.8v 1529.505n 1.8v 1539.495n 1.8v 1539.505n 1.8v 1549.495n 1.8v 1549.505n 1.8v 1559.495n 1.8v 1559.505n 0.0v 1569.495n 0.0v 1569.505n 0.0v 1579.495n 0.0v 1579.505n 0.0v 1589.495n 0.0v 1589.505n 1.8v 1599.495n 1.8v 1599.505n 1.8v 1609.495n 1.8v 1609.505n 1.8v 1619.495n 1.8v 1619.505n 1.8v 1629.495n 1.8v 1629.505n 1.8v 1639.495n 1.8v 1639.505n 1.8v 1649.495n 1.8v 1649.505n 1.8v 1659.495n 1.8v 1659.505n 1.8v 1669.495n 1.8v 1669.505n 1.8v 1679.495n 1.8v 1679.505n 1.8v 1689.495n 1.8v 1689.505n 1.8v 1699.495n 1.8v 1699.505n 1.8v 1709.495n 1.8v 1709.505n 1.8v 1719.495n 1.8v 1719.505n 1.8v 1729.495n 1.8v 1729.505n 1.8v 1739.495n 1.8v 1739.505n 1.8v 1749.495n 1.8v 1749.505n 1.8v 1759.495n 1.8v 1759.505n 1.8v 1769.495n 1.8v 1769.505n 1.8v 1779.495n 1.8v 1779.505n 0.0v 1789.495n 0.0v 1789.505n 1.8v 1799.495n 1.8v 1799.505n 0.0v 1809.495n 0.0v 1809.505n 0.0v 1819.495n 0.0v 1819.505n 0.0v 1829.495n 0.0v 1829.505n 0.0v 1839.495n 0.0v 1839.505n 0.0v 1849.495n 0.0v 1849.505n 0.0v 1859.495n 0.0v 1859.505n 0.0v 1869.495n 0.0v 1869.505n 0.0v 1879.495n 0.0v 1879.505n 1.8v 1889.495n 1.8v 1889.505n 1.8v 1899.495n 1.8v 1899.505n 0.0v 1909.495n 0.0v 1909.505n 0.0v 1919.495n 0.0v 1919.505n 0.0v 1929.495n 0.0v 1929.505n 1.8v 1939.495n 1.8v 1939.505n 1.8v 1949.495n 1.8v 1949.505n 1.8v 1959.495n 1.8v 1959.505n 1.8v 1969.495n 1.8v 1969.505n 1.8v 1979.495n 1.8v 1979.505n 0.0v 1989.495n 0.0v 1989.505n 0.0v 1999.495n 0.0v 1999.505n 0.0v 2009.495n 0.0v 2009.505n 1.8v 2019.495n 1.8v 2019.505n 1.8v 2029.495n 1.8v 2029.505n 1.8v 2039.495n 1.8v 2039.505n 1.8v 2049.495n 1.8v 2049.505n 1.8v )
* (time, data): [(0, 0), (10, 0), (20, 1), (30, 0), (40, 0), (50, 0), (60, 0), (70, 0), (80, 0), (90, 1), (100, 1), (110, 1), (120, 1), (130, 1), (140, 1), (150, 1), (160, 1), (170, 1), (180, 1), (190, 1), (200, 1), (210, 1), (220, 0), (230, 0), (240, 0), (250, 1), (260, 1), (270, 1), (280, 1), (290, 1), (300, 1), (310, 1), (320, 1), (330, 1), (340, 1), (350, 1), (360, 0), (370, 0), (380, 1), (390, 1), (400, 1), (410, 0), (420, 0), (430, 0), (440, 0), (450, 0), (460, 0), (470, 0), (480, 0), (490, 0), (500, 0), (510, 1), (520, 1), (530, 1), (540, 0), (550, 0), (560, 0), (570, 0), (580, 0), (590, 0), (600, 0), (610, 0), (620, 0), (630, 1), (640, 1), (650, 1), (660, 1), (670, 0), (680, 0), (690, 0), (700, 1), (710, 1), (720, 1), (730, 1), (740, 1), (750, 1), (760, 0), (770, 1), (780, 1), (790, 1), (800, 1), (810, 1), (820, 1), (830, 1), (840, 1), (850, 1), (860, 1), (870, 1), (880, 1), (890, 1), (900, 1), (910, 1), (920, 0), (930, 0), (940, 0), (950, 0), (960, 0), (970, 1), (980, 1), (990, 1), (1000, 0), (1010, 0), (1020, 1), (1030, 1), (1040, 1), (1050, 1), (1060, 1), (1070, 1), (1080, 1), (1090, 1), (1100, 1), (1110, 1), (1120, 1), (1130, 1), (1140, 1), (1150, 1), (1160, 0), (1170, 1), (1180, 1), (1190, 1), (1200, 0), (1210, 0), (1220, 0), (1230, 0), (1240, 0), (1250, 0), (1260, 0), (1270, 0), (1280, 0), (1290, 0), (1300, 0), (1310, 0), (1320, 0), (1330, 0), (1340, 0), (1350, 0), (1360, 0), (1370, 1), (1380, 1), (1390, 1), (1400, 1), (1410, 1), (1420, 1), (1430, 1), (1440, 0), (1450, 0), (1460, 0), (1470, 1), (1480, 1), (1490, 1), (1500, 1), (1510, 1), (1520, 1), (1530, 1), (1540, 1), (1550, 1), (1560, 0), (1570, 0), (1580, 0), (1590, 0), (1600, 0), (1610, 0), (1620, 0), (1630, 0), (1640, 0), (1650, 0), (1660, 0), (1670, 0), (1680, 0), (1690, 0), (1700, 0), (1710, 0), (1720, 1), (1730, 1), (1740, 1), (1750, 1), (1760, 1), (1770, 1), (1780, 0), (1790, 0), (1800, 0), (1810, 1), (1820, 1), (1830, 1), (1840, 1), (1850, 1), (1860, 1), (1870, 1), (1880, 1), (1890, 1), (1900, 0), (1910, 0), (1920, 0), (1930, 1), (1940, 1), (1950, 1), (1960, 1), (1970, 1), (1980, 0), (1990, 0), (2000, 0), (2010, 0), (2020, 0), (2030, 0), (2040, 0), (2050, 0)]
Vdin0_4  din0_4  0 PWL (0n 0.0v 9.495n 0.0v 9.505n 0.0v 19.495n 0.0v 19.505n 1.8v 29.495n 1.8v 29.505n 0.0v 39.495n 0.0v 39.505n 0.0v 49.495n 0.0v 49.505n 0.0v 59.495n 0.0v 59.505n 0.0v 69.495n 0.0v 69.505n 0.0v 79.495n 0.0v 79.505n 0.0v 89.495n 0.0v 89.505n 1.8v 99.495n 1.8v 99.505n 1.8v 109.495n 1.8v 109.505n 1.8v 119.495n 1.8v 119.505n 1.8v 129.495n 1.8v 129.505n 1.8v 139.495n 1.8v 139.505n 1.8v 149.495n 1.8v 149.505n 1.8v 159.495n 1.8v 159.505n 1.8v 169.495n 1.8v 169.505n 1.8v 179.495n 1.8v 179.505n 1.8v 189.495n 1.8v 189.505n 1.8v 199.495n 1.8v 199.505n 1.8v 209.495n 1.8v 209.505n 1.8v 219.495n 1.8v 219.505n 0.0v 229.495n 0.0v 229.505n 0.0v 239.495n 0.0v 239.505n 0.0v 249.495n 0.0v 249.505n 1.8v 259.495n 1.8v 259.505n 1.8v 269.495n 1.8v 269.505n 1.8v 279.495n 1.8v 279.505n 1.8v 289.495n 1.8v 289.505n 1.8v 299.495n 1.8v 299.505n 1.8v 309.495n 1.8v 309.505n 1.8v 319.495n 1.8v 319.505n 1.8v 329.495n 1.8v 329.505n 1.8v 339.495n 1.8v 339.505n 1.8v 349.495n 1.8v 349.505n 1.8v 359.495n 1.8v 359.505n 0.0v 369.495n 0.0v 369.505n 0.0v 379.495n 0.0v 379.505n 1.8v 389.495n 1.8v 389.505n 1.8v 399.495n 1.8v 399.505n 1.8v 409.495n 1.8v 409.505n 0.0v 419.495n 0.0v 419.505n 0.0v 429.495n 0.0v 429.505n 0.0v 439.495n 0.0v 439.505n 0.0v 449.495n 0.0v 449.505n 0.0v 459.495n 0.0v 459.505n 0.0v 469.495n 0.0v 469.505n 0.0v 479.495n 0.0v 479.505n 0.0v 489.495n 0.0v 489.505n 0.0v 499.495n 0.0v 499.505n 0.0v 509.495n 0.0v 509.505n 1.8v 519.495n 1.8v 519.505n 1.8v 529.495n 1.8v 529.505n 1.8v 539.495n 1.8v 539.505n 0.0v 549.495n 0.0v 549.505n 0.0v 559.495n 0.0v 559.505n 0.0v 569.495n 0.0v 569.505n 0.0v 579.495n 0.0v 579.505n 0.0v 589.495n 0.0v 589.505n 0.0v 599.495n 0.0v 599.505n 0.0v 609.495n 0.0v 609.505n 0.0v 619.495n 0.0v 619.505n 0.0v 629.495n 0.0v 629.505n 1.8v 639.495n 1.8v 639.505n 1.8v 649.495n 1.8v 649.505n 1.8v 659.495n 1.8v 659.505n 1.8v 669.495n 1.8v 669.505n 0.0v 679.495n 0.0v 679.505n 0.0v 689.495n 0.0v 689.505n 0.0v 699.495n 0.0v 699.505n 1.8v 709.495n 1.8v 709.505n 1.8v 719.495n 1.8v 719.505n 1.8v 729.495n 1.8v 729.505n 1.8v 739.495n 1.8v 739.505n 1.8v 749.495n 1.8v 749.505n 1.8v 759.495n 1.8v 759.505n 0.0v 769.495n 0.0v 769.505n 1.8v 779.495n 1.8v 779.505n 1.8v 789.495n 1.8v 789.505n 1.8v 799.495n 1.8v 799.505n 1.8v 809.495n 1.8v 809.505n 1.8v 819.495n 1.8v 819.505n 1.8v 829.495n 1.8v 829.505n 1.8v 839.495n 1.8v 839.505n 1.8v 849.495n 1.8v 849.505n 1.8v 859.495n 1.8v 859.505n 1.8v 869.495n 1.8v 869.505n 1.8v 879.495n 1.8v 879.505n 1.8v 889.495n 1.8v 889.505n 1.8v 899.495n 1.8v 899.505n 1.8v 909.495n 1.8v 909.505n 1.8v 919.495n 1.8v 919.505n 0.0v 929.495n 0.0v 929.505n 0.0v 939.495n 0.0v 939.505n 0.0v 949.495n 0.0v 949.505n 0.0v 959.495n 0.0v 959.505n 0.0v 969.495n 0.0v 969.505n 1.8v 979.495n 1.8v 979.505n 1.8v 989.495n 1.8v 989.505n 1.8v 999.495n 1.8v 999.505n 0.0v 1009.495n 0.0v 1009.505n 0.0v 1019.495n 0.0v 1019.505n 1.8v 1029.495n 1.8v 1029.505n 1.8v 1039.495n 1.8v 1039.505n 1.8v 1049.495n 1.8v 1049.505n 1.8v 1059.495n 1.8v 1059.505n 1.8v 1069.495n 1.8v 1069.505n 1.8v 1079.495n 1.8v 1079.505n 1.8v 1089.495n 1.8v 1089.505n 1.8v 1099.495n 1.8v 1099.505n 1.8v 1109.495n 1.8v 1109.505n 1.8v 1119.495n 1.8v 1119.505n 1.8v 1129.495n 1.8v 1129.505n 1.8v 1139.495n 1.8v 1139.505n 1.8v 1149.495n 1.8v 1149.505n 1.8v 1159.495n 1.8v 1159.505n 0.0v 1169.495n 0.0v 1169.505n 1.8v 1179.495n 1.8v 1179.505n 1.8v 1189.495n 1.8v 1189.505n 1.8v 1199.495n 1.8v 1199.505n 0.0v 1209.495n 0.0v 1209.505n 0.0v 1219.495n 0.0v 1219.505n 0.0v 1229.495n 0.0v 1229.505n 0.0v 1239.495n 0.0v 1239.505n 0.0v 1249.495n 0.0v 1249.505n 0.0v 1259.495n 0.0v 1259.505n 0.0v 1269.495n 0.0v 1269.505n 0.0v 1279.495n 0.0v 1279.505n 0.0v 1289.495n 0.0v 1289.505n 0.0v 1299.495n 0.0v 1299.505n 0.0v 1309.495n 0.0v 1309.505n 0.0v 1319.495n 0.0v 1319.505n 0.0v 1329.495n 0.0v 1329.505n 0.0v 1339.495n 0.0v 1339.505n 0.0v 1349.495n 0.0v 1349.505n 0.0v 1359.495n 0.0v 1359.505n 0.0v 1369.495n 0.0v 1369.505n 1.8v 1379.495n 1.8v 1379.505n 1.8v 1389.495n 1.8v 1389.505n 1.8v 1399.495n 1.8v 1399.505n 1.8v 1409.495n 1.8v 1409.505n 1.8v 1419.495n 1.8v 1419.505n 1.8v 1429.495n 1.8v 1429.505n 1.8v 1439.495n 1.8v 1439.505n 0.0v 1449.495n 0.0v 1449.505n 0.0v 1459.495n 0.0v 1459.505n 0.0v 1469.495n 0.0v 1469.505n 1.8v 1479.495n 1.8v 1479.505n 1.8v 1489.495n 1.8v 1489.505n 1.8v 1499.495n 1.8v 1499.505n 1.8v 1509.495n 1.8v 1509.505n 1.8v 1519.495n 1.8v 1519.505n 1.8v 1529.495n 1.8v 1529.505n 1.8v 1539.495n 1.8v 1539.505n 1.8v 1549.495n 1.8v 1549.505n 1.8v 1559.495n 1.8v 1559.505n 0.0v 1569.495n 0.0v 1569.505n 0.0v 1579.495n 0.0v 1579.505n 0.0v 1589.495n 0.0v 1589.505n 0.0v 1599.495n 0.0v 1599.505n 0.0v 1609.495n 0.0v 1609.505n 0.0v 1619.495n 0.0v 1619.505n 0.0v 1629.495n 0.0v 1629.505n 0.0v 1639.495n 0.0v 1639.505n 0.0v 1649.495n 0.0v 1649.505n 0.0v 1659.495n 0.0v 1659.505n 0.0v 1669.495n 0.0v 1669.505n 0.0v 1679.495n 0.0v 1679.505n 0.0v 1689.495n 0.0v 1689.505n 0.0v 1699.495n 0.0v 1699.505n 0.0v 1709.495n 0.0v 1709.505n 0.0v 1719.495n 0.0v 1719.505n 1.8v 1729.495n 1.8v 1729.505n 1.8v 1739.495n 1.8v 1739.505n 1.8v 1749.495n 1.8v 1749.505n 1.8v 1759.495n 1.8v 1759.505n 1.8v 1769.495n 1.8v 1769.505n 1.8v 1779.495n 1.8v 1779.505n 0.0v 1789.495n 0.0v 1789.505n 0.0v 1799.495n 0.0v 1799.505n 0.0v 1809.495n 0.0v 1809.505n 1.8v 1819.495n 1.8v 1819.505n 1.8v 1829.495n 1.8v 1829.505n 1.8v 1839.495n 1.8v 1839.505n 1.8v 1849.495n 1.8v 1849.505n 1.8v 1859.495n 1.8v 1859.505n 1.8v 1869.495n 1.8v 1869.505n 1.8v 1879.495n 1.8v 1879.505n 1.8v 1889.495n 1.8v 1889.505n 1.8v 1899.495n 1.8v 1899.505n 0.0v 1909.495n 0.0v 1909.505n 0.0v 1919.495n 0.0v 1919.505n 0.0v 1929.495n 0.0v 1929.505n 1.8v 1939.495n 1.8v 1939.505n 1.8v 1949.495n 1.8v 1949.505n 1.8v 1959.495n 1.8v 1959.505n 1.8v 1969.495n 1.8v 1969.505n 1.8v 1979.495n 1.8v 1979.505n 0.0v 1989.495n 0.0v 1989.505n 0.0v 1999.495n 0.0v 1999.505n 0.0v 2009.495n 0.0v 2009.505n 0.0v 2019.495n 0.0v 2019.505n 0.0v 2029.495n 0.0v 2029.505n 0.0v 2039.495n 0.0v 2039.505n 0.0v 2049.495n 0.0v 2049.505n 0.0v )
* (time, data): [(0, 0), (10, 1), (20, 0), (30, 1), (40, 1), (50, 1), (60, 0), (70, 0), (80, 0), (90, 1), (100, 1), (110, 1), (120, 1), (130, 1), (140, 1), (150, 1), (160, 1), (170, 1), (180, 1), (190, 1), (200, 1), (210, 1), (220, 1), (230, 1), (240, 1), (250, 1), (260, 1), (270, 1), (280, 1), (290, 1), (300, 1), (310, 1), (320, 0), (330, 0), (340, 0), (350, 0), (360, 1), (370, 1), (380, 1), (390, 1), (400, 1), (410, 0), (420, 0), (430, 0), (440, 1), (450, 1), (460, 1), (470, 1), (480, 1), (490, 0), (500, 0), (510, 1), (520, 1), (530, 1), (540, 0), (550, 1), (560, 1), (570, 1), (580, 0), (590, 0), (600, 0), (610, 0), (620, 0), (630, 0), (640, 0), (650, 0), (660, 1), (670, 0), (680, 0), (690, 0), (700, 1), (710, 1), (720, 1), (730, 1), (740, 0), (750, 0), (760, 0), (770, 0), (780, 1), (790, 1), (800, 1), (810, 1), (820, 1), (830, 1), (840, 0), (850, 0), (860, 0), (870, 1), (880, 1), (890, 1), (900, 1), (910, 1), (920, 0), (930, 0), (940, 0), (950, 0), (960, 0), (970, 0), (980, 0), (990, 0), (1000, 0), (1010, 0), (1020, 0), (1030, 0), (1040, 0), (1050, 0), (1060, 0), (1070, 0), (1080, 0), (1090, 0), (1100, 0), (1110, 0), (1120, 1), (1130, 1), (1140, 1), (1150, 1), (1160, 1), (1170, 0), (1180, 0), (1190, 0), (1200, 0), (1210, 0), (1220, 0), (1230, 1), (1240, 1), (1250, 0), (1260, 0), (1270, 0), (1280, 0), (1290, 0), (1300, 0), (1310, 0), (1320, 1), (1330, 1), (1340, 1), (1350, 1), (1360, 0), (1370, 1), (1380, 1), (1390, 1), (1400, 1), (1410, 1), (1420, 1), (1430, 1), (1440, 0), (1450, 0), (1460, 0), (1470, 1), (1480, 1), (1490, 1), (1500, 1), (1510, 1), (1520, 1), (1530, 1), (1540, 1), (1550, 0), (1560, 0), (1570, 0), (1580, 0), (1590, 0), (1600, 0), (1610, 0), (1620, 0), (1630, 0), (1640, 1), (1650, 1), (1660, 1), (1670, 1), (1680, 1), (1690, 1), (1700, 1), (1710, 1), (1720, 1), (1730, 1), (1740, 1), (1750, 1), (1760, 1), (1770, 1), (1780, 0), (1790, 1), (1800, 1), (1810, 0), (1820, 0), (1830, 0), (1840, 0), (1850, 0), (1860, 0), (1870, 0), (1880, 0), (1890, 0), (1900, 0), (1910, 1), (1920, 1), (1930, 1), (1940, 1), (1950, 1), (1960, 1), (1970, 1), (1980, 0), (1990, 0), (2000, 0), (2010, 0), (2020, 0), (2030, 0), (2040, 0), (2050, 0)]
Vdin0_5  din0_5  0 PWL (0n 0.0v 9.495n 0.0v 9.505n 1.8v 19.495n 1.8v 19.505n 0.0v 29.495n 0.0v 29.505n 1.8v 39.495n 1.8v 39.505n 1.8v 49.495n 1.8v 49.505n 1.8v 59.495n 1.8v 59.505n 0.0v 69.495n 0.0v 69.505n 0.0v 79.495n 0.0v 79.505n 0.0v 89.495n 0.0v 89.505n 1.8v 99.495n 1.8v 99.505n 1.8v 109.495n 1.8v 109.505n 1.8v 119.495n 1.8v 119.505n 1.8v 129.495n 1.8v 129.505n 1.8v 139.495n 1.8v 139.505n 1.8v 149.495n 1.8v 149.505n 1.8v 159.495n 1.8v 159.505n 1.8v 169.495n 1.8v 169.505n 1.8v 179.495n 1.8v 179.505n 1.8v 189.495n 1.8v 189.505n 1.8v 199.495n 1.8v 199.505n 1.8v 209.495n 1.8v 209.505n 1.8v 219.495n 1.8v 219.505n 1.8v 229.495n 1.8v 229.505n 1.8v 239.495n 1.8v 239.505n 1.8v 249.495n 1.8v 249.505n 1.8v 259.495n 1.8v 259.505n 1.8v 269.495n 1.8v 269.505n 1.8v 279.495n 1.8v 279.505n 1.8v 289.495n 1.8v 289.505n 1.8v 299.495n 1.8v 299.505n 1.8v 309.495n 1.8v 309.505n 1.8v 319.495n 1.8v 319.505n 0.0v 329.495n 0.0v 329.505n 0.0v 339.495n 0.0v 339.505n 0.0v 349.495n 0.0v 349.505n 0.0v 359.495n 0.0v 359.505n 1.8v 369.495n 1.8v 369.505n 1.8v 379.495n 1.8v 379.505n 1.8v 389.495n 1.8v 389.505n 1.8v 399.495n 1.8v 399.505n 1.8v 409.495n 1.8v 409.505n 0.0v 419.495n 0.0v 419.505n 0.0v 429.495n 0.0v 429.505n 0.0v 439.495n 0.0v 439.505n 1.8v 449.495n 1.8v 449.505n 1.8v 459.495n 1.8v 459.505n 1.8v 469.495n 1.8v 469.505n 1.8v 479.495n 1.8v 479.505n 1.8v 489.495n 1.8v 489.505n 0.0v 499.495n 0.0v 499.505n 0.0v 509.495n 0.0v 509.505n 1.8v 519.495n 1.8v 519.505n 1.8v 529.495n 1.8v 529.505n 1.8v 539.495n 1.8v 539.505n 0.0v 549.495n 0.0v 549.505n 1.8v 559.495n 1.8v 559.505n 1.8v 569.495n 1.8v 569.505n 1.8v 579.495n 1.8v 579.505n 0.0v 589.495n 0.0v 589.505n 0.0v 599.495n 0.0v 599.505n 0.0v 609.495n 0.0v 609.505n 0.0v 619.495n 0.0v 619.505n 0.0v 629.495n 0.0v 629.505n 0.0v 639.495n 0.0v 639.505n 0.0v 649.495n 0.0v 649.505n 0.0v 659.495n 0.0v 659.505n 1.8v 669.495n 1.8v 669.505n 0.0v 679.495n 0.0v 679.505n 0.0v 689.495n 0.0v 689.505n 0.0v 699.495n 0.0v 699.505n 1.8v 709.495n 1.8v 709.505n 1.8v 719.495n 1.8v 719.505n 1.8v 729.495n 1.8v 729.505n 1.8v 739.495n 1.8v 739.505n 0.0v 749.495n 0.0v 749.505n 0.0v 759.495n 0.0v 759.505n 0.0v 769.495n 0.0v 769.505n 0.0v 779.495n 0.0v 779.505n 1.8v 789.495n 1.8v 789.505n 1.8v 799.495n 1.8v 799.505n 1.8v 809.495n 1.8v 809.505n 1.8v 819.495n 1.8v 819.505n 1.8v 829.495n 1.8v 829.505n 1.8v 839.495n 1.8v 839.505n 0.0v 849.495n 0.0v 849.505n 0.0v 859.495n 0.0v 859.505n 0.0v 869.495n 0.0v 869.505n 1.8v 879.495n 1.8v 879.505n 1.8v 889.495n 1.8v 889.505n 1.8v 899.495n 1.8v 899.505n 1.8v 909.495n 1.8v 909.505n 1.8v 919.495n 1.8v 919.505n 0.0v 929.495n 0.0v 929.505n 0.0v 939.495n 0.0v 939.505n 0.0v 949.495n 0.0v 949.505n 0.0v 959.495n 0.0v 959.505n 0.0v 969.495n 0.0v 969.505n 0.0v 979.495n 0.0v 979.505n 0.0v 989.495n 0.0v 989.505n 0.0v 999.495n 0.0v 999.505n 0.0v 1009.495n 0.0v 1009.505n 0.0v 1019.495n 0.0v 1019.505n 0.0v 1029.495n 0.0v 1029.505n 0.0v 1039.495n 0.0v 1039.505n 0.0v 1049.495n 0.0v 1049.505n 0.0v 1059.495n 0.0v 1059.505n 0.0v 1069.495n 0.0v 1069.505n 0.0v 1079.495n 0.0v 1079.505n 0.0v 1089.495n 0.0v 1089.505n 0.0v 1099.495n 0.0v 1099.505n 0.0v 1109.495n 0.0v 1109.505n 0.0v 1119.495n 0.0v 1119.505n 1.8v 1129.495n 1.8v 1129.505n 1.8v 1139.495n 1.8v 1139.505n 1.8v 1149.495n 1.8v 1149.505n 1.8v 1159.495n 1.8v 1159.505n 1.8v 1169.495n 1.8v 1169.505n 0.0v 1179.495n 0.0v 1179.505n 0.0v 1189.495n 0.0v 1189.505n 0.0v 1199.495n 0.0v 1199.505n 0.0v 1209.495n 0.0v 1209.505n 0.0v 1219.495n 0.0v 1219.505n 0.0v 1229.495n 0.0v 1229.505n 1.8v 1239.495n 1.8v 1239.505n 1.8v 1249.495n 1.8v 1249.505n 0.0v 1259.495n 0.0v 1259.505n 0.0v 1269.495n 0.0v 1269.505n 0.0v 1279.495n 0.0v 1279.505n 0.0v 1289.495n 0.0v 1289.505n 0.0v 1299.495n 0.0v 1299.505n 0.0v 1309.495n 0.0v 1309.505n 0.0v 1319.495n 0.0v 1319.505n 1.8v 1329.495n 1.8v 1329.505n 1.8v 1339.495n 1.8v 1339.505n 1.8v 1349.495n 1.8v 1349.505n 1.8v 1359.495n 1.8v 1359.505n 0.0v 1369.495n 0.0v 1369.505n 1.8v 1379.495n 1.8v 1379.505n 1.8v 1389.495n 1.8v 1389.505n 1.8v 1399.495n 1.8v 1399.505n 1.8v 1409.495n 1.8v 1409.505n 1.8v 1419.495n 1.8v 1419.505n 1.8v 1429.495n 1.8v 1429.505n 1.8v 1439.495n 1.8v 1439.505n 0.0v 1449.495n 0.0v 1449.505n 0.0v 1459.495n 0.0v 1459.505n 0.0v 1469.495n 0.0v 1469.505n 1.8v 1479.495n 1.8v 1479.505n 1.8v 1489.495n 1.8v 1489.505n 1.8v 1499.495n 1.8v 1499.505n 1.8v 1509.495n 1.8v 1509.505n 1.8v 1519.495n 1.8v 1519.505n 1.8v 1529.495n 1.8v 1529.505n 1.8v 1539.495n 1.8v 1539.505n 1.8v 1549.495n 1.8v 1549.505n 0.0v 1559.495n 0.0v 1559.505n 0.0v 1569.495n 0.0v 1569.505n 0.0v 1579.495n 0.0v 1579.505n 0.0v 1589.495n 0.0v 1589.505n 0.0v 1599.495n 0.0v 1599.505n 0.0v 1609.495n 0.0v 1609.505n 0.0v 1619.495n 0.0v 1619.505n 0.0v 1629.495n 0.0v 1629.505n 0.0v 1639.495n 0.0v 1639.505n 1.8v 1649.495n 1.8v 1649.505n 1.8v 1659.495n 1.8v 1659.505n 1.8v 1669.495n 1.8v 1669.505n 1.8v 1679.495n 1.8v 1679.505n 1.8v 1689.495n 1.8v 1689.505n 1.8v 1699.495n 1.8v 1699.505n 1.8v 1709.495n 1.8v 1709.505n 1.8v 1719.495n 1.8v 1719.505n 1.8v 1729.495n 1.8v 1729.505n 1.8v 1739.495n 1.8v 1739.505n 1.8v 1749.495n 1.8v 1749.505n 1.8v 1759.495n 1.8v 1759.505n 1.8v 1769.495n 1.8v 1769.505n 1.8v 1779.495n 1.8v 1779.505n 0.0v 1789.495n 0.0v 1789.505n 1.8v 1799.495n 1.8v 1799.505n 1.8v 1809.495n 1.8v 1809.505n 0.0v 1819.495n 0.0v 1819.505n 0.0v 1829.495n 0.0v 1829.505n 0.0v 1839.495n 0.0v 1839.505n 0.0v 1849.495n 0.0v 1849.505n 0.0v 1859.495n 0.0v 1859.505n 0.0v 1869.495n 0.0v 1869.505n 0.0v 1879.495n 0.0v 1879.505n 0.0v 1889.495n 0.0v 1889.505n 0.0v 1899.495n 0.0v 1899.505n 0.0v 1909.495n 0.0v 1909.505n 1.8v 1919.495n 1.8v 1919.505n 1.8v 1929.495n 1.8v 1929.505n 1.8v 1939.495n 1.8v 1939.505n 1.8v 1949.495n 1.8v 1949.505n 1.8v 1959.495n 1.8v 1959.505n 1.8v 1969.495n 1.8v 1969.505n 1.8v 1979.495n 1.8v 1979.505n 0.0v 1989.495n 0.0v 1989.505n 0.0v 1999.495n 0.0v 1999.505n 0.0v 2009.495n 0.0v 2009.505n 0.0v 2019.495n 0.0v 2019.505n 0.0v 2029.495n 0.0v 2029.505n 0.0v 2039.495n 0.0v 2039.505n 0.0v 2049.495n 0.0v 2049.505n 0.0v )
* (time, data): [(0, 0), (10, 0), (20, 0), (30, 0), (40, 0), (50, 0), (60, 1), (70, 1), (80, 1), (90, 1), (100, 1), (110, 1), (120, 0), (130, 0), (140, 0), (150, 0), (160, 0), (170, 0), (180, 0), (190, 0), (200, 0), (210, 0), (220, 1), (230, 1), (240, 1), (250, 0), (260, 0), (270, 0), (280, 0), (290, 0), (300, 0), (310, 0), (320, 0), (330, 0), (340, 0), (350, 0), (360, 0), (370, 0), (380, 1), (390, 1), (400, 1), (410, 1), (420, 1), (430, 1), (440, 0), (450, 0), (460, 0), (470, 0), (480, 0), (490, 1), (500, 1), (510, 1), (520, 1), (530, 1), (540, 0), (550, 1), (560, 1), (570, 1), (580, 1), (590, 1), (600, 1), (610, 1), (620, 1), (630, 0), (640, 0), (650, 0), (660, 1), (670, 1), (680, 1), (690, 1), (700, 1), (710, 1), (720, 1), (730, 0), (740, 0), (750, 0), (760, 0), (770, 1), (780, 1), (790, 1), (800, 1), (810, 1), (820, 1), (830, 1), (840, 0), (850, 0), (860, 0), (870, 1), (880, 1), (890, 1), (900, 1), (910, 1), (920, 1), (930, 1), (940, 1), (950, 1), (960, 1), (970, 0), (980, 1), (990, 1), (1000, 0), (1010, 0), (1020, 1), (1030, 1), (1040, 1), (1050, 1), (1060, 1), (1070, 1), (1080, 1), (1090, 1), (1100, 1), (1110, 1), (1120, 0), (1130, 0), (1140, 1), (1150, 1), (1160, 0), (1170, 0), (1180, 0), (1190, 0), (1200, 0), (1210, 0), (1220, 0), (1230, 1), (1240, 1), (1250, 0), (1260, 1), (1270, 0), (1280, 0), (1290, 0), (1300, 0), (1310, 0), (1320, 0), (1330, 0), (1340, 1), (1350, 1), (1360, 1), (1370, 0), (1380, 0), (1390, 0), (1400, 0), (1410, 0), (1420, 0), (1430, 0), (1440, 0), (1450, 0), (1460, 1), (1470, 0), (1480, 0), (1490, 0), (1500, 0), (1510, 0), (1520, 0), (1530, 0), (1540, 0), (1550, 1), (1560, 1), (1570, 1), (1580, 1), (1590, 0), (1600, 0), (1610, 0), (1620, 0), (1630, 0), (1640, 0), (1650, 0), (1660, 0), (1670, 0), (1680, 0), (1690, 0), (1700, 0), (1710, 0), (1720, 0), (1730, 0), (1740, 0), (1750, 0), (1760, 0), (1770, 0), (1780, 0), (1790, 0), (1800, 1), (1810, 0), (1820, 0), (1830, 0), (1840, 0), (1850, 0), (1860, 0), (1870, 0), (1880, 1), (1890, 1), (1900, 1), (1910, 1), (1920, 1), (1930, 0), (1940, 0), (1950, 0), (1960, 0), (1970, 0), (1980, 0), (1990, 0), (2000, 0), (2010, 0), (2020, 0), (2030, 0), (2040, 0), (2050, 0)]
Vdin0_6  din0_6  0 PWL (0n 0.0v 9.495n 0.0v 9.505n 0.0v 19.495n 0.0v 19.505n 0.0v 29.495n 0.0v 29.505n 0.0v 39.495n 0.0v 39.505n 0.0v 49.495n 0.0v 49.505n 0.0v 59.495n 0.0v 59.505n 1.8v 69.495n 1.8v 69.505n 1.8v 79.495n 1.8v 79.505n 1.8v 89.495n 1.8v 89.505n 1.8v 99.495n 1.8v 99.505n 1.8v 109.495n 1.8v 109.505n 1.8v 119.495n 1.8v 119.505n 0.0v 129.495n 0.0v 129.505n 0.0v 139.495n 0.0v 139.505n 0.0v 149.495n 0.0v 149.505n 0.0v 159.495n 0.0v 159.505n 0.0v 169.495n 0.0v 169.505n 0.0v 179.495n 0.0v 179.505n 0.0v 189.495n 0.0v 189.505n 0.0v 199.495n 0.0v 199.505n 0.0v 209.495n 0.0v 209.505n 0.0v 219.495n 0.0v 219.505n 1.8v 229.495n 1.8v 229.505n 1.8v 239.495n 1.8v 239.505n 1.8v 249.495n 1.8v 249.505n 0.0v 259.495n 0.0v 259.505n 0.0v 269.495n 0.0v 269.505n 0.0v 279.495n 0.0v 279.505n 0.0v 289.495n 0.0v 289.505n 0.0v 299.495n 0.0v 299.505n 0.0v 309.495n 0.0v 309.505n 0.0v 319.495n 0.0v 319.505n 0.0v 329.495n 0.0v 329.505n 0.0v 339.495n 0.0v 339.505n 0.0v 349.495n 0.0v 349.505n 0.0v 359.495n 0.0v 359.505n 0.0v 369.495n 0.0v 369.505n 0.0v 379.495n 0.0v 379.505n 1.8v 389.495n 1.8v 389.505n 1.8v 399.495n 1.8v 399.505n 1.8v 409.495n 1.8v 409.505n 1.8v 419.495n 1.8v 419.505n 1.8v 429.495n 1.8v 429.505n 1.8v 439.495n 1.8v 439.505n 0.0v 449.495n 0.0v 449.505n 0.0v 459.495n 0.0v 459.505n 0.0v 469.495n 0.0v 469.505n 0.0v 479.495n 0.0v 479.505n 0.0v 489.495n 0.0v 489.505n 1.8v 499.495n 1.8v 499.505n 1.8v 509.495n 1.8v 509.505n 1.8v 519.495n 1.8v 519.505n 1.8v 529.495n 1.8v 529.505n 1.8v 539.495n 1.8v 539.505n 0.0v 549.495n 0.0v 549.505n 1.8v 559.495n 1.8v 559.505n 1.8v 569.495n 1.8v 569.505n 1.8v 579.495n 1.8v 579.505n 1.8v 589.495n 1.8v 589.505n 1.8v 599.495n 1.8v 599.505n 1.8v 609.495n 1.8v 609.505n 1.8v 619.495n 1.8v 619.505n 1.8v 629.495n 1.8v 629.505n 0.0v 639.495n 0.0v 639.505n 0.0v 649.495n 0.0v 649.505n 0.0v 659.495n 0.0v 659.505n 1.8v 669.495n 1.8v 669.505n 1.8v 679.495n 1.8v 679.505n 1.8v 689.495n 1.8v 689.505n 1.8v 699.495n 1.8v 699.505n 1.8v 709.495n 1.8v 709.505n 1.8v 719.495n 1.8v 719.505n 1.8v 729.495n 1.8v 729.505n 0.0v 739.495n 0.0v 739.505n 0.0v 749.495n 0.0v 749.505n 0.0v 759.495n 0.0v 759.505n 0.0v 769.495n 0.0v 769.505n 1.8v 779.495n 1.8v 779.505n 1.8v 789.495n 1.8v 789.505n 1.8v 799.495n 1.8v 799.505n 1.8v 809.495n 1.8v 809.505n 1.8v 819.495n 1.8v 819.505n 1.8v 829.495n 1.8v 829.505n 1.8v 839.495n 1.8v 839.505n 0.0v 849.495n 0.0v 849.505n 0.0v 859.495n 0.0v 859.505n 0.0v 869.495n 0.0v 869.505n 1.8v 879.495n 1.8v 879.505n 1.8v 889.495n 1.8v 889.505n 1.8v 899.495n 1.8v 899.505n 1.8v 909.495n 1.8v 909.505n 1.8v 919.495n 1.8v 919.505n 1.8v 929.495n 1.8v 929.505n 1.8v 939.495n 1.8v 939.505n 1.8v 949.495n 1.8v 949.505n 1.8v 959.495n 1.8v 959.505n 1.8v 969.495n 1.8v 969.505n 0.0v 979.495n 0.0v 979.505n 1.8v 989.495n 1.8v 989.505n 1.8v 999.495n 1.8v 999.505n 0.0v 1009.495n 0.0v 1009.505n 0.0v 1019.495n 0.0v 1019.505n 1.8v 1029.495n 1.8v 1029.505n 1.8v 1039.495n 1.8v 1039.505n 1.8v 1049.495n 1.8v 1049.505n 1.8v 1059.495n 1.8v 1059.505n 1.8v 1069.495n 1.8v 1069.505n 1.8v 1079.495n 1.8v 1079.505n 1.8v 1089.495n 1.8v 1089.505n 1.8v 1099.495n 1.8v 1099.505n 1.8v 1109.495n 1.8v 1109.505n 1.8v 1119.495n 1.8v 1119.505n 0.0v 1129.495n 0.0v 1129.505n 0.0v 1139.495n 0.0v 1139.505n 1.8v 1149.495n 1.8v 1149.505n 1.8v 1159.495n 1.8v 1159.505n 0.0v 1169.495n 0.0v 1169.505n 0.0v 1179.495n 0.0v 1179.505n 0.0v 1189.495n 0.0v 1189.505n 0.0v 1199.495n 0.0v 1199.505n 0.0v 1209.495n 0.0v 1209.505n 0.0v 1219.495n 0.0v 1219.505n 0.0v 1229.495n 0.0v 1229.505n 1.8v 1239.495n 1.8v 1239.505n 1.8v 1249.495n 1.8v 1249.505n 0.0v 1259.495n 0.0v 1259.505n 1.8v 1269.495n 1.8v 1269.505n 0.0v 1279.495n 0.0v 1279.505n 0.0v 1289.495n 0.0v 1289.505n 0.0v 1299.495n 0.0v 1299.505n 0.0v 1309.495n 0.0v 1309.505n 0.0v 1319.495n 0.0v 1319.505n 0.0v 1329.495n 0.0v 1329.505n 0.0v 1339.495n 0.0v 1339.505n 1.8v 1349.495n 1.8v 1349.505n 1.8v 1359.495n 1.8v 1359.505n 1.8v 1369.495n 1.8v 1369.505n 0.0v 1379.495n 0.0v 1379.505n 0.0v 1389.495n 0.0v 1389.505n 0.0v 1399.495n 0.0v 1399.505n 0.0v 1409.495n 0.0v 1409.505n 0.0v 1419.495n 0.0v 1419.505n 0.0v 1429.495n 0.0v 1429.505n 0.0v 1439.495n 0.0v 1439.505n 0.0v 1449.495n 0.0v 1449.505n 0.0v 1459.495n 0.0v 1459.505n 1.8v 1469.495n 1.8v 1469.505n 0.0v 1479.495n 0.0v 1479.505n 0.0v 1489.495n 0.0v 1489.505n 0.0v 1499.495n 0.0v 1499.505n 0.0v 1509.495n 0.0v 1509.505n 0.0v 1519.495n 0.0v 1519.505n 0.0v 1529.495n 0.0v 1529.505n 0.0v 1539.495n 0.0v 1539.505n 0.0v 1549.495n 0.0v 1549.505n 1.8v 1559.495n 1.8v 1559.505n 1.8v 1569.495n 1.8v 1569.505n 1.8v 1579.495n 1.8v 1579.505n 1.8v 1589.495n 1.8v 1589.505n 0.0v 1599.495n 0.0v 1599.505n 0.0v 1609.495n 0.0v 1609.505n 0.0v 1619.495n 0.0v 1619.505n 0.0v 1629.495n 0.0v 1629.505n 0.0v 1639.495n 0.0v 1639.505n 0.0v 1649.495n 0.0v 1649.505n 0.0v 1659.495n 0.0v 1659.505n 0.0v 1669.495n 0.0v 1669.505n 0.0v 1679.495n 0.0v 1679.505n 0.0v 1689.495n 0.0v 1689.505n 0.0v 1699.495n 0.0v 1699.505n 0.0v 1709.495n 0.0v 1709.505n 0.0v 1719.495n 0.0v 1719.505n 0.0v 1729.495n 0.0v 1729.505n 0.0v 1739.495n 0.0v 1739.505n 0.0v 1749.495n 0.0v 1749.505n 0.0v 1759.495n 0.0v 1759.505n 0.0v 1769.495n 0.0v 1769.505n 0.0v 1779.495n 0.0v 1779.505n 0.0v 1789.495n 0.0v 1789.505n 0.0v 1799.495n 0.0v 1799.505n 1.8v 1809.495n 1.8v 1809.505n 0.0v 1819.495n 0.0v 1819.505n 0.0v 1829.495n 0.0v 1829.505n 0.0v 1839.495n 0.0v 1839.505n 0.0v 1849.495n 0.0v 1849.505n 0.0v 1859.495n 0.0v 1859.505n 0.0v 1869.495n 0.0v 1869.505n 0.0v 1879.495n 0.0v 1879.505n 1.8v 1889.495n 1.8v 1889.505n 1.8v 1899.495n 1.8v 1899.505n 1.8v 1909.495n 1.8v 1909.505n 1.8v 1919.495n 1.8v 1919.505n 1.8v 1929.495n 1.8v 1929.505n 0.0v 1939.495n 0.0v 1939.505n 0.0v 1949.495n 0.0v 1949.505n 0.0v 1959.495n 0.0v 1959.505n 0.0v 1969.495n 0.0v 1969.505n 0.0v 1979.495n 0.0v 1979.505n 0.0v 1989.495n 0.0v 1989.505n 0.0v 1999.495n 0.0v 1999.505n 0.0v 2009.495n 0.0v 2009.505n 0.0v 2019.495n 0.0v 2019.505n 0.0v 2029.495n 0.0v 2029.505n 0.0v 2039.495n 0.0v 2039.505n 0.0v 2049.495n 0.0v 2049.505n 0.0v )
* (time, data): [(0, 0), (10, 0), (20, 0), (30, 1), (40, 1), (50, 1), (60, 1), (70, 1), (80, 1), (90, 0), (100, 0), (110, 0), (120, 1), (130, 1), (140, 1), (150, 1), (160, 1), (170, 1), (180, 1), (190, 1), (200, 1), (210, 1), (220, 0), (230, 0), (240, 0), (250, 0), (260, 0), (270, 0), (280, 0), (290, 0), (300, 0), (310, 0), (320, 1), (330, 1), (340, 1), (350, 1), (360, 1), (370, 1), (380, 1), (390, 1), (400, 1), (410, 0), (420, 1), (430, 1), (440, 1), (450, 1), (460, 1), (470, 1), (480, 1), (490, 0), (500, 0), (510, 1), (520, 1), (530, 1), (540, 0), (550, 0), (560, 0), (570, 0), (580, 0), (590, 0), (600, 0), (610, 0), (620, 0), (630, 0), (640, 0), (650, 0), (660, 0), (670, 0), (680, 0), (690, 0), (700, 1), (710, 1), (720, 1), (730, 1), (740, 0), (750, 0), (760, 0), (770, 0), (780, 0), (790, 0), (800, 1), (810, 1), (820, 1), (830, 1), (840, 0), (850, 0), (860, 0), (870, 1), (880, 1), (890, 1), (900, 1), (910, 1), (920, 0), (930, 0), (940, 0), (950, 0), (960, 0), (970, 1), (980, 1), (990, 1), (1000, 0), (1010, 0), (1020, 0), (1030, 0), (1040, 0), (1050, 0), (1060, 0), (1070, 0), (1080, 0), (1090, 0), (1100, 0), (1110, 0), (1120, 1), (1130, 1), (1140, 1), (1150, 1), (1160, 1), (1170, 0), (1180, 0), (1190, 0), (1200, 0), (1210, 0), (1220, 0), (1230, 1), (1240, 1), (1250, 1), (1260, 0), (1270, 1), (1280, 1), (1290, 1), (1300, 1), (1310, 1), (1320, 0), (1330, 1), (1340, 1), (1350, 0), (1360, 1), (1370, 1), (1380, 1), (1390, 1), (1400, 1), (1410, 1), (1420, 1), (1430, 1), (1440, 0), (1450, 0), (1460, 1), (1470, 1), (1480, 1), (1490, 1), (1500, 1), (1510, 1), (1520, 1), (1530, 1), (1540, 1), (1550, 1), (1560, 0), (1570, 0), (1580, 0), (1590, 1), (1600, 1), (1610, 1), (1620, 1), (1630, 1), (1640, 1), (1650, 1), (1660, 1), (1670, 1), (1680, 1), (1690, 1), (1700, 1), (1710, 1), (1720, 0), (1730, 0), (1740, 0), (1750, 0), (1760, 0), (1770, 1), (1780, 1), (1790, 1), (1800, 0), (1810, 0), (1820, 0), (1830, 0), (1840, 0), (1850, 0), (1860, 0), (1870, 0), (1880, 1), (1890, 1), (1900, 0), (1910, 0), (1920, 0), (1930, 0), (1940, 0), (1950, 0), (1960, 0), (1970, 0), (1980, 0), (1990, 0), (2000, 0), (2010, 1), (2020, 1), (2030, 1), (2040, 1), (2050, 1)]
Vdin0_7  din0_7  0 PWL (0n 0.0v 9.495n 0.0v 9.505n 0.0v 19.495n 0.0v 19.505n 0.0v 29.495n 0.0v 29.505n 1.8v 39.495n 1.8v 39.505n 1.8v 49.495n 1.8v 49.505n 1.8v 59.495n 1.8v 59.505n 1.8v 69.495n 1.8v 69.505n 1.8v 79.495n 1.8v 79.505n 1.8v 89.495n 1.8v 89.505n 0.0v 99.495n 0.0v 99.505n 0.0v 109.495n 0.0v 109.505n 0.0v 119.495n 0.0v 119.505n 1.8v 129.495n 1.8v 129.505n 1.8v 139.495n 1.8v 139.505n 1.8v 149.495n 1.8v 149.505n 1.8v 159.495n 1.8v 159.505n 1.8v 169.495n 1.8v 169.505n 1.8v 179.495n 1.8v 179.505n 1.8v 189.495n 1.8v 189.505n 1.8v 199.495n 1.8v 199.505n 1.8v 209.495n 1.8v 209.505n 1.8v 219.495n 1.8v 219.505n 0.0v 229.495n 0.0v 229.505n 0.0v 239.495n 0.0v 239.505n 0.0v 249.495n 0.0v 249.505n 0.0v 259.495n 0.0v 259.505n 0.0v 269.495n 0.0v 269.505n 0.0v 279.495n 0.0v 279.505n 0.0v 289.495n 0.0v 289.505n 0.0v 299.495n 0.0v 299.505n 0.0v 309.495n 0.0v 309.505n 0.0v 319.495n 0.0v 319.505n 1.8v 329.495n 1.8v 329.505n 1.8v 339.495n 1.8v 339.505n 1.8v 349.495n 1.8v 349.505n 1.8v 359.495n 1.8v 359.505n 1.8v 369.495n 1.8v 369.505n 1.8v 379.495n 1.8v 379.505n 1.8v 389.495n 1.8v 389.505n 1.8v 399.495n 1.8v 399.505n 1.8v 409.495n 1.8v 409.505n 0.0v 419.495n 0.0v 419.505n 1.8v 429.495n 1.8v 429.505n 1.8v 439.495n 1.8v 439.505n 1.8v 449.495n 1.8v 449.505n 1.8v 459.495n 1.8v 459.505n 1.8v 469.495n 1.8v 469.505n 1.8v 479.495n 1.8v 479.505n 1.8v 489.495n 1.8v 489.505n 0.0v 499.495n 0.0v 499.505n 0.0v 509.495n 0.0v 509.505n 1.8v 519.495n 1.8v 519.505n 1.8v 529.495n 1.8v 529.505n 1.8v 539.495n 1.8v 539.505n 0.0v 549.495n 0.0v 549.505n 0.0v 559.495n 0.0v 559.505n 0.0v 569.495n 0.0v 569.505n 0.0v 579.495n 0.0v 579.505n 0.0v 589.495n 0.0v 589.505n 0.0v 599.495n 0.0v 599.505n 0.0v 609.495n 0.0v 609.505n 0.0v 619.495n 0.0v 619.505n 0.0v 629.495n 0.0v 629.505n 0.0v 639.495n 0.0v 639.505n 0.0v 649.495n 0.0v 649.505n 0.0v 659.495n 0.0v 659.505n 0.0v 669.495n 0.0v 669.505n 0.0v 679.495n 0.0v 679.505n 0.0v 689.495n 0.0v 689.505n 0.0v 699.495n 0.0v 699.505n 1.8v 709.495n 1.8v 709.505n 1.8v 719.495n 1.8v 719.505n 1.8v 729.495n 1.8v 729.505n 1.8v 739.495n 1.8v 739.505n 0.0v 749.495n 0.0v 749.505n 0.0v 759.495n 0.0v 759.505n 0.0v 769.495n 0.0v 769.505n 0.0v 779.495n 0.0v 779.505n 0.0v 789.495n 0.0v 789.505n 0.0v 799.495n 0.0v 799.505n 1.8v 809.495n 1.8v 809.505n 1.8v 819.495n 1.8v 819.505n 1.8v 829.495n 1.8v 829.505n 1.8v 839.495n 1.8v 839.505n 0.0v 849.495n 0.0v 849.505n 0.0v 859.495n 0.0v 859.505n 0.0v 869.495n 0.0v 869.505n 1.8v 879.495n 1.8v 879.505n 1.8v 889.495n 1.8v 889.505n 1.8v 899.495n 1.8v 899.505n 1.8v 909.495n 1.8v 909.505n 1.8v 919.495n 1.8v 919.505n 0.0v 929.495n 0.0v 929.505n 0.0v 939.495n 0.0v 939.505n 0.0v 949.495n 0.0v 949.505n 0.0v 959.495n 0.0v 959.505n 0.0v 969.495n 0.0v 969.505n 1.8v 979.495n 1.8v 979.505n 1.8v 989.495n 1.8v 989.505n 1.8v 999.495n 1.8v 999.505n 0.0v 1009.495n 0.0v 1009.505n 0.0v 1019.495n 0.0v 1019.505n 0.0v 1029.495n 0.0v 1029.505n 0.0v 1039.495n 0.0v 1039.505n 0.0v 1049.495n 0.0v 1049.505n 0.0v 1059.495n 0.0v 1059.505n 0.0v 1069.495n 0.0v 1069.505n 0.0v 1079.495n 0.0v 1079.505n 0.0v 1089.495n 0.0v 1089.505n 0.0v 1099.495n 0.0v 1099.505n 0.0v 1109.495n 0.0v 1109.505n 0.0v 1119.495n 0.0v 1119.505n 1.8v 1129.495n 1.8v 1129.505n 1.8v 1139.495n 1.8v 1139.505n 1.8v 1149.495n 1.8v 1149.505n 1.8v 1159.495n 1.8v 1159.505n 1.8v 1169.495n 1.8v 1169.505n 0.0v 1179.495n 0.0v 1179.505n 0.0v 1189.495n 0.0v 1189.505n 0.0v 1199.495n 0.0v 1199.505n 0.0v 1209.495n 0.0v 1209.505n 0.0v 1219.495n 0.0v 1219.505n 0.0v 1229.495n 0.0v 1229.505n 1.8v 1239.495n 1.8v 1239.505n 1.8v 1249.495n 1.8v 1249.505n 1.8v 1259.495n 1.8v 1259.505n 0.0v 1269.495n 0.0v 1269.505n 1.8v 1279.495n 1.8v 1279.505n 1.8v 1289.495n 1.8v 1289.505n 1.8v 1299.495n 1.8v 1299.505n 1.8v 1309.495n 1.8v 1309.505n 1.8v 1319.495n 1.8v 1319.505n 0.0v 1329.495n 0.0v 1329.505n 1.8v 1339.495n 1.8v 1339.505n 1.8v 1349.495n 1.8v 1349.505n 0.0v 1359.495n 0.0v 1359.505n 1.8v 1369.495n 1.8v 1369.505n 1.8v 1379.495n 1.8v 1379.505n 1.8v 1389.495n 1.8v 1389.505n 1.8v 1399.495n 1.8v 1399.505n 1.8v 1409.495n 1.8v 1409.505n 1.8v 1419.495n 1.8v 1419.505n 1.8v 1429.495n 1.8v 1429.505n 1.8v 1439.495n 1.8v 1439.505n 0.0v 1449.495n 0.0v 1449.505n 0.0v 1459.495n 0.0v 1459.505n 1.8v 1469.495n 1.8v 1469.505n 1.8v 1479.495n 1.8v 1479.505n 1.8v 1489.495n 1.8v 1489.505n 1.8v 1499.495n 1.8v 1499.505n 1.8v 1509.495n 1.8v 1509.505n 1.8v 1519.495n 1.8v 1519.505n 1.8v 1529.495n 1.8v 1529.505n 1.8v 1539.495n 1.8v 1539.505n 1.8v 1549.495n 1.8v 1549.505n 1.8v 1559.495n 1.8v 1559.505n 0.0v 1569.495n 0.0v 1569.505n 0.0v 1579.495n 0.0v 1579.505n 0.0v 1589.495n 0.0v 1589.505n 1.8v 1599.495n 1.8v 1599.505n 1.8v 1609.495n 1.8v 1609.505n 1.8v 1619.495n 1.8v 1619.505n 1.8v 1629.495n 1.8v 1629.505n 1.8v 1639.495n 1.8v 1639.505n 1.8v 1649.495n 1.8v 1649.505n 1.8v 1659.495n 1.8v 1659.505n 1.8v 1669.495n 1.8v 1669.505n 1.8v 1679.495n 1.8v 1679.505n 1.8v 1689.495n 1.8v 1689.505n 1.8v 1699.495n 1.8v 1699.505n 1.8v 1709.495n 1.8v 1709.505n 1.8v 1719.495n 1.8v 1719.505n 0.0v 1729.495n 0.0v 1729.505n 0.0v 1739.495n 0.0v 1739.505n 0.0v 1749.495n 0.0v 1749.505n 0.0v 1759.495n 0.0v 1759.505n 0.0v 1769.495n 0.0v 1769.505n 1.8v 1779.495n 1.8v 1779.505n 1.8v 1789.495n 1.8v 1789.505n 1.8v 1799.495n 1.8v 1799.505n 0.0v 1809.495n 0.0v 1809.505n 0.0v 1819.495n 0.0v 1819.505n 0.0v 1829.495n 0.0v 1829.505n 0.0v 1839.495n 0.0v 1839.505n 0.0v 1849.495n 0.0v 1849.505n 0.0v 1859.495n 0.0v 1859.505n 0.0v 1869.495n 0.0v 1869.505n 0.0v 1879.495n 0.0v 1879.505n 1.8v 1889.495n 1.8v 1889.505n 1.8v 1899.495n 1.8v 1899.505n 0.0v 1909.495n 0.0v 1909.505n 0.0v 1919.495n 0.0v 1919.505n 0.0v 1929.495n 0.0v 1929.505n 0.0v 1939.495n 0.0v 1939.505n 0.0v 1949.495n 0.0v 1949.505n 0.0v 1959.495n 0.0v 1959.505n 0.0v 1969.495n 0.0v 1969.505n 0.0v 1979.495n 0.0v 1979.505n 0.0v 1989.495n 0.0v 1989.505n 0.0v 1999.495n 0.0v 1999.505n 0.0v 2009.495n 0.0v 2009.505n 1.8v 2019.495n 1.8v 2019.505n 1.8v 2029.495n 1.8v 2029.505n 1.8v 2039.495n 1.8v 2039.505n 1.8v 2049.495n 1.8v 2049.505n 1.8v )
* (time, data): [(0, 0), (10, 0), (20, 0), (30, 0), (40, 0), (50, 0), (60, 1), (70, 1), (80, 1), (90, 0), (100, 0), (110, 0), (120, 0), (130, 0), (140, 0), (150, 0), (160, 0), (170, 0), (180, 0), (190, 0), (200, 0), (210, 0), (220, 0), (230, 0), (240, 0), (250, 1), (260, 1), (270, 1), (280, 1), (290, 1), (300, 1), (310, 1), (320, 1), (330, 1), (340, 1), (350, 1), (360, 0), (370, 0), (380, 0), (390, 0), (400, 0), (410, 0), (420, 1), (430, 1), (440, 1), (450, 1), (460, 1), (470, 1), (480, 1), (490, 1), (500, 1), (510, 1), (520, 1), (530, 0), (540, 1), (550, 1), (560, 1), (570, 1), (580, 1), (590, 1), (600, 1), (610, 1), (620, 1), (630, 0), (640, 0), (650, 0), (660, 1), (670, 0), (680, 0), (690, 0), (700, 1), (710, 1), (720, 1), (730, 0), (740, 0), (750, 0), (760, 0), (770, 1), (780, 0), (790, 0), (800, 0), (810, 0), (820, 0), (830, 0), (840, 1), (850, 1), (860, 1), (870, 0), (880, 0), (890, 0), (900, 0), (910, 0), (920, 1), (930, 1), (940, 1), (950, 1), (960, 1), (970, 0), (980, 0), (990, 0), (1000, 1), (1010, 1), (1020, 0), (1030, 0), (1040, 0), (1050, 0), (1060, 0), (1070, 0), (1080, 0), (1090, 0), (1100, 0), (1110, 0), (1120, 1), (1130, 1), (1140, 1), (1150, 1), (1160, 1), (1170, 0), (1180, 0), (1190, 0), (1200, 1), (1210, 1), (1220, 1), (1230, 1), (1240, 0), (1250, 1), (1260, 1), (1270, 1), (1280, 1), (1290, 1), (1300, 1), (1310, 1), (1320, 0), (1330, 0), (1340, 0), (1350, 0), (1360, 0), (1370, 1), (1380, 1), (1390, 1), (1400, 1), (1410, 1), (1420, 1), (1430, 1), (1440, 1), (1450, 1), (1460, 1), (1470, 0), (1480, 0), (1490, 0), (1500, 0), (1510, 0), (1520, 0), (1530, 0), (1540, 0), (1550, 0), (1560, 0), (1570, 0), (1580, 0), (1590, 0), (1600, 0), (1610, 0), (1620, 0), (1630, 0), (1640, 1), (1650, 1), (1660, 1), (1670, 1), (1680, 1), (1690, 1), (1700, 1), (1710, 1), (1720, 1), (1730, 1), (1740, 1), (1750, 1), (1760, 1), (1770, 1), (1780, 0), (1790, 0), (1800, 0), (1810, 0), (1820, 0), (1830, 0), (1840, 0), (1850, 0), (1860, 0), (1870, 0), (1880, 1), (1890, 1), (1900, 0), (1910, 0), (1920, 0), (1930, 0), (1940, 0), (1950, 0), (1960, 0), (1970, 0), (1980, 0), (1990, 0), (2000, 0), (2010, 0), (2020, 0), (2030, 0), (2040, 0), (2050, 0)]
Vdin0_8  din0_8  0 PWL (0n 0.0v 9.495n 0.0v 9.505n 0.0v 19.495n 0.0v 19.505n 0.0v 29.495n 0.0v 29.505n 0.0v 39.495n 0.0v 39.505n 0.0v 49.495n 0.0v 49.505n 0.0v 59.495n 0.0v 59.505n 1.8v 69.495n 1.8v 69.505n 1.8v 79.495n 1.8v 79.505n 1.8v 89.495n 1.8v 89.505n 0.0v 99.495n 0.0v 99.505n 0.0v 109.495n 0.0v 109.505n 0.0v 119.495n 0.0v 119.505n 0.0v 129.495n 0.0v 129.505n 0.0v 139.495n 0.0v 139.505n 0.0v 149.495n 0.0v 149.505n 0.0v 159.495n 0.0v 159.505n 0.0v 169.495n 0.0v 169.505n 0.0v 179.495n 0.0v 179.505n 0.0v 189.495n 0.0v 189.505n 0.0v 199.495n 0.0v 199.505n 0.0v 209.495n 0.0v 209.505n 0.0v 219.495n 0.0v 219.505n 0.0v 229.495n 0.0v 229.505n 0.0v 239.495n 0.0v 239.505n 0.0v 249.495n 0.0v 249.505n 1.8v 259.495n 1.8v 259.505n 1.8v 269.495n 1.8v 269.505n 1.8v 279.495n 1.8v 279.505n 1.8v 289.495n 1.8v 289.505n 1.8v 299.495n 1.8v 299.505n 1.8v 309.495n 1.8v 309.505n 1.8v 319.495n 1.8v 319.505n 1.8v 329.495n 1.8v 329.505n 1.8v 339.495n 1.8v 339.505n 1.8v 349.495n 1.8v 349.505n 1.8v 359.495n 1.8v 359.505n 0.0v 369.495n 0.0v 369.505n 0.0v 379.495n 0.0v 379.505n 0.0v 389.495n 0.0v 389.505n 0.0v 399.495n 0.0v 399.505n 0.0v 409.495n 0.0v 409.505n 0.0v 419.495n 0.0v 419.505n 1.8v 429.495n 1.8v 429.505n 1.8v 439.495n 1.8v 439.505n 1.8v 449.495n 1.8v 449.505n 1.8v 459.495n 1.8v 459.505n 1.8v 469.495n 1.8v 469.505n 1.8v 479.495n 1.8v 479.505n 1.8v 489.495n 1.8v 489.505n 1.8v 499.495n 1.8v 499.505n 1.8v 509.495n 1.8v 509.505n 1.8v 519.495n 1.8v 519.505n 1.8v 529.495n 1.8v 529.505n 0.0v 539.495n 0.0v 539.505n 1.8v 549.495n 1.8v 549.505n 1.8v 559.495n 1.8v 559.505n 1.8v 569.495n 1.8v 569.505n 1.8v 579.495n 1.8v 579.505n 1.8v 589.495n 1.8v 589.505n 1.8v 599.495n 1.8v 599.505n 1.8v 609.495n 1.8v 609.505n 1.8v 619.495n 1.8v 619.505n 1.8v 629.495n 1.8v 629.505n 0.0v 639.495n 0.0v 639.505n 0.0v 649.495n 0.0v 649.505n 0.0v 659.495n 0.0v 659.505n 1.8v 669.495n 1.8v 669.505n 0.0v 679.495n 0.0v 679.505n 0.0v 689.495n 0.0v 689.505n 0.0v 699.495n 0.0v 699.505n 1.8v 709.495n 1.8v 709.505n 1.8v 719.495n 1.8v 719.505n 1.8v 729.495n 1.8v 729.505n 0.0v 739.495n 0.0v 739.505n 0.0v 749.495n 0.0v 749.505n 0.0v 759.495n 0.0v 759.505n 0.0v 769.495n 0.0v 769.505n 1.8v 779.495n 1.8v 779.505n 0.0v 789.495n 0.0v 789.505n 0.0v 799.495n 0.0v 799.505n 0.0v 809.495n 0.0v 809.505n 0.0v 819.495n 0.0v 819.505n 0.0v 829.495n 0.0v 829.505n 0.0v 839.495n 0.0v 839.505n 1.8v 849.495n 1.8v 849.505n 1.8v 859.495n 1.8v 859.505n 1.8v 869.495n 1.8v 869.505n 0.0v 879.495n 0.0v 879.505n 0.0v 889.495n 0.0v 889.505n 0.0v 899.495n 0.0v 899.505n 0.0v 909.495n 0.0v 909.505n 0.0v 919.495n 0.0v 919.505n 1.8v 929.495n 1.8v 929.505n 1.8v 939.495n 1.8v 939.505n 1.8v 949.495n 1.8v 949.505n 1.8v 959.495n 1.8v 959.505n 1.8v 969.495n 1.8v 969.505n 0.0v 979.495n 0.0v 979.505n 0.0v 989.495n 0.0v 989.505n 0.0v 999.495n 0.0v 999.505n 1.8v 1009.495n 1.8v 1009.505n 1.8v 1019.495n 1.8v 1019.505n 0.0v 1029.495n 0.0v 1029.505n 0.0v 1039.495n 0.0v 1039.505n 0.0v 1049.495n 0.0v 1049.505n 0.0v 1059.495n 0.0v 1059.505n 0.0v 1069.495n 0.0v 1069.505n 0.0v 1079.495n 0.0v 1079.505n 0.0v 1089.495n 0.0v 1089.505n 0.0v 1099.495n 0.0v 1099.505n 0.0v 1109.495n 0.0v 1109.505n 0.0v 1119.495n 0.0v 1119.505n 1.8v 1129.495n 1.8v 1129.505n 1.8v 1139.495n 1.8v 1139.505n 1.8v 1149.495n 1.8v 1149.505n 1.8v 1159.495n 1.8v 1159.505n 1.8v 1169.495n 1.8v 1169.505n 0.0v 1179.495n 0.0v 1179.505n 0.0v 1189.495n 0.0v 1189.505n 0.0v 1199.495n 0.0v 1199.505n 1.8v 1209.495n 1.8v 1209.505n 1.8v 1219.495n 1.8v 1219.505n 1.8v 1229.495n 1.8v 1229.505n 1.8v 1239.495n 1.8v 1239.505n 0.0v 1249.495n 0.0v 1249.505n 1.8v 1259.495n 1.8v 1259.505n 1.8v 1269.495n 1.8v 1269.505n 1.8v 1279.495n 1.8v 1279.505n 1.8v 1289.495n 1.8v 1289.505n 1.8v 1299.495n 1.8v 1299.505n 1.8v 1309.495n 1.8v 1309.505n 1.8v 1319.495n 1.8v 1319.505n 0.0v 1329.495n 0.0v 1329.505n 0.0v 1339.495n 0.0v 1339.505n 0.0v 1349.495n 0.0v 1349.505n 0.0v 1359.495n 0.0v 1359.505n 0.0v 1369.495n 0.0v 1369.505n 1.8v 1379.495n 1.8v 1379.505n 1.8v 1389.495n 1.8v 1389.505n 1.8v 1399.495n 1.8v 1399.505n 1.8v 1409.495n 1.8v 1409.505n 1.8v 1419.495n 1.8v 1419.505n 1.8v 1429.495n 1.8v 1429.505n 1.8v 1439.495n 1.8v 1439.505n 1.8v 1449.495n 1.8v 1449.505n 1.8v 1459.495n 1.8v 1459.505n 1.8v 1469.495n 1.8v 1469.505n 0.0v 1479.495n 0.0v 1479.505n 0.0v 1489.495n 0.0v 1489.505n 0.0v 1499.495n 0.0v 1499.505n 0.0v 1509.495n 0.0v 1509.505n 0.0v 1519.495n 0.0v 1519.505n 0.0v 1529.495n 0.0v 1529.505n 0.0v 1539.495n 0.0v 1539.505n 0.0v 1549.495n 0.0v 1549.505n 0.0v 1559.495n 0.0v 1559.505n 0.0v 1569.495n 0.0v 1569.505n 0.0v 1579.495n 0.0v 1579.505n 0.0v 1589.495n 0.0v 1589.505n 0.0v 1599.495n 0.0v 1599.505n 0.0v 1609.495n 0.0v 1609.505n 0.0v 1619.495n 0.0v 1619.505n 0.0v 1629.495n 0.0v 1629.505n 0.0v 1639.495n 0.0v 1639.505n 1.8v 1649.495n 1.8v 1649.505n 1.8v 1659.495n 1.8v 1659.505n 1.8v 1669.495n 1.8v 1669.505n 1.8v 1679.495n 1.8v 1679.505n 1.8v 1689.495n 1.8v 1689.505n 1.8v 1699.495n 1.8v 1699.505n 1.8v 1709.495n 1.8v 1709.505n 1.8v 1719.495n 1.8v 1719.505n 1.8v 1729.495n 1.8v 1729.505n 1.8v 1739.495n 1.8v 1739.505n 1.8v 1749.495n 1.8v 1749.505n 1.8v 1759.495n 1.8v 1759.505n 1.8v 1769.495n 1.8v 1769.505n 1.8v 1779.495n 1.8v 1779.505n 0.0v 1789.495n 0.0v 1789.505n 0.0v 1799.495n 0.0v 1799.505n 0.0v 1809.495n 0.0v 1809.505n 0.0v 1819.495n 0.0v 1819.505n 0.0v 1829.495n 0.0v 1829.505n 0.0v 1839.495n 0.0v 1839.505n 0.0v 1849.495n 0.0v 1849.505n 0.0v 1859.495n 0.0v 1859.505n 0.0v 1869.495n 0.0v 1869.505n 0.0v 1879.495n 0.0v 1879.505n 1.8v 1889.495n 1.8v 1889.505n 1.8v 1899.495n 1.8v 1899.505n 0.0v 1909.495n 0.0v 1909.505n 0.0v 1919.495n 0.0v 1919.505n 0.0v 1929.495n 0.0v 1929.505n 0.0v 1939.495n 0.0v 1939.505n 0.0v 1949.495n 0.0v 1949.505n 0.0v 1959.495n 0.0v 1959.505n 0.0v 1969.495n 0.0v 1969.505n 0.0v 1979.495n 0.0v 1979.505n 0.0v 1989.495n 0.0v 1989.505n 0.0v 1999.495n 0.0v 1999.505n 0.0v 2009.495n 0.0v 2009.505n 0.0v 2019.495n 0.0v 2019.505n 0.0v 2029.495n 0.0v 2029.505n 0.0v 2039.495n 0.0v 2039.505n 0.0v 2049.495n 0.0v 2049.505n 0.0v )
* (time, data): [(0, 0), (10, 1), (20, 1), (30, 1), (40, 1), (50, 1), (60, 0), (70, 0), (80, 0), (90, 1), (100, 1), (110, 1), (120, 0), (130, 0), (140, 0), (150, 0), (160, 0), (170, 0), (180, 0), (190, 0), (200, 1), (210, 1), (220, 1), (230, 1), (240, 1), (250, 1), (260, 1), (270, 1), (280, 1), (290, 1), (300, 1), (310, 1), (320, 0), (330, 0), (340, 0), (350, 0), (360, 0), (370, 0), (380, 0), (390, 0), (400, 0), (410, 1), (420, 1), (430, 1), (440, 0), (450, 0), (460, 0), (470, 0), (480, 0), (490, 1), (500, 1), (510, 0), (520, 0), (530, 0), (540, 1), (550, 0), (560, 0), (570, 0), (580, 1), (590, 1), (600, 1), (610, 1), (620, 1), (630, 1), (640, 1), (650, 1), (660, 0), (670, 0), (680, 0), (690, 0), (700, 0), (710, 0), (720, 0), (730, 1), (740, 1), (750, 1), (760, 0), (770, 0), (780, 0), (790, 0), (800, 0), (810, 0), (820, 0), (830, 0), (840, 0), (850, 0), (860, 0), (870, 1), (880, 1), (890, 1), (900, 1), (910, 1), (920, 0), (930, 0), (940, 0), (950, 0), (960, 0), (970, 1), (980, 1), (990, 1), (1000, 0), (1010, 0), (1020, 1), (1030, 1), (1040, 1), (1050, 1), (1060, 1), (1070, 1), (1080, 1), (1090, 1), (1100, 1), (1110, 1), (1120, 0), (1130, 0), (1140, 1), (1150, 1), (1160, 0), (1170, 1), (1180, 1), (1190, 1), (1200, 0), (1210, 0), (1220, 0), (1230, 0), (1240, 0), (1250, 1), (1260, 0), (1270, 1), (1280, 1), (1290, 1), (1300, 1), (1310, 1), (1320, 1), (1330, 1), (1340, 1), (1350, 1), (1360, 1), (1370, 0), (1380, 0), (1390, 0), (1400, 0), (1410, 0), (1420, 0), (1430, 0), (1440, 0), (1450, 0), (1460, 1), (1470, 0), (1480, 0), (1490, 0), (1500, 0), (1510, 0), (1520, 0), (1530, 0), (1540, 0), (1550, 1), (1560, 1), (1570, 1), (1580, 1), (1590, 0), (1600, 0), (1610, 0), (1620, 0), (1630, 0), (1640, 0), (1650, 0), (1660, 0), (1670, 0), (1680, 0), (1690, 0), (1700, 0), (1710, 0), (1720, 1), (1730, 1), (1740, 1), (1750, 1), (1760, 1), (1770, 1), (1780, 0), (1790, 1), (1800, 0), (1810, 0), (1820, 0), (1830, 0), (1840, 0), (1850, 0), (1860, 0), (1870, 0), (1880, 0), (1890, 0), (1900, 0), (1910, 1), (1920, 1), (1930, 0), (1940, 0), (1950, 0), (1960, 0), (1970, 0), (1980, 1), (1990, 1), (2000, 1), (2010, 1), (2020, 1), (2030, 1), (2040, 1), (2050, 1)]
Vdin0_9  din0_9  0 PWL (0n 0.0v 9.495n 0.0v 9.505n 1.8v 19.495n 1.8v 19.505n 1.8v 29.495n 1.8v 29.505n 1.8v 39.495n 1.8v 39.505n 1.8v 49.495n 1.8v 49.505n 1.8v 59.495n 1.8v 59.505n 0.0v 69.495n 0.0v 69.505n 0.0v 79.495n 0.0v 79.505n 0.0v 89.495n 0.0v 89.505n 1.8v 99.495n 1.8v 99.505n 1.8v 109.495n 1.8v 109.505n 1.8v 119.495n 1.8v 119.505n 0.0v 129.495n 0.0v 129.505n 0.0v 139.495n 0.0v 139.505n 0.0v 149.495n 0.0v 149.505n 0.0v 159.495n 0.0v 159.505n 0.0v 169.495n 0.0v 169.505n 0.0v 179.495n 0.0v 179.505n 0.0v 189.495n 0.0v 189.505n 0.0v 199.495n 0.0v 199.505n 1.8v 209.495n 1.8v 209.505n 1.8v 219.495n 1.8v 219.505n 1.8v 229.495n 1.8v 229.505n 1.8v 239.495n 1.8v 239.505n 1.8v 249.495n 1.8v 249.505n 1.8v 259.495n 1.8v 259.505n 1.8v 269.495n 1.8v 269.505n 1.8v 279.495n 1.8v 279.505n 1.8v 289.495n 1.8v 289.505n 1.8v 299.495n 1.8v 299.505n 1.8v 309.495n 1.8v 309.505n 1.8v 319.495n 1.8v 319.505n 0.0v 329.495n 0.0v 329.505n 0.0v 339.495n 0.0v 339.505n 0.0v 349.495n 0.0v 349.505n 0.0v 359.495n 0.0v 359.505n 0.0v 369.495n 0.0v 369.505n 0.0v 379.495n 0.0v 379.505n 0.0v 389.495n 0.0v 389.505n 0.0v 399.495n 0.0v 399.505n 0.0v 409.495n 0.0v 409.505n 1.8v 419.495n 1.8v 419.505n 1.8v 429.495n 1.8v 429.505n 1.8v 439.495n 1.8v 439.505n 0.0v 449.495n 0.0v 449.505n 0.0v 459.495n 0.0v 459.505n 0.0v 469.495n 0.0v 469.505n 0.0v 479.495n 0.0v 479.505n 0.0v 489.495n 0.0v 489.505n 1.8v 499.495n 1.8v 499.505n 1.8v 509.495n 1.8v 509.505n 0.0v 519.495n 0.0v 519.505n 0.0v 529.495n 0.0v 529.505n 0.0v 539.495n 0.0v 539.505n 1.8v 549.495n 1.8v 549.505n 0.0v 559.495n 0.0v 559.505n 0.0v 569.495n 0.0v 569.505n 0.0v 579.495n 0.0v 579.505n 1.8v 589.495n 1.8v 589.505n 1.8v 599.495n 1.8v 599.505n 1.8v 609.495n 1.8v 609.505n 1.8v 619.495n 1.8v 619.505n 1.8v 629.495n 1.8v 629.505n 1.8v 639.495n 1.8v 639.505n 1.8v 649.495n 1.8v 649.505n 1.8v 659.495n 1.8v 659.505n 0.0v 669.495n 0.0v 669.505n 0.0v 679.495n 0.0v 679.505n 0.0v 689.495n 0.0v 689.505n 0.0v 699.495n 0.0v 699.505n 0.0v 709.495n 0.0v 709.505n 0.0v 719.495n 0.0v 719.505n 0.0v 729.495n 0.0v 729.505n 1.8v 739.495n 1.8v 739.505n 1.8v 749.495n 1.8v 749.505n 1.8v 759.495n 1.8v 759.505n 0.0v 769.495n 0.0v 769.505n 0.0v 779.495n 0.0v 779.505n 0.0v 789.495n 0.0v 789.505n 0.0v 799.495n 0.0v 799.505n 0.0v 809.495n 0.0v 809.505n 0.0v 819.495n 0.0v 819.505n 0.0v 829.495n 0.0v 829.505n 0.0v 839.495n 0.0v 839.505n 0.0v 849.495n 0.0v 849.505n 0.0v 859.495n 0.0v 859.505n 0.0v 869.495n 0.0v 869.505n 1.8v 879.495n 1.8v 879.505n 1.8v 889.495n 1.8v 889.505n 1.8v 899.495n 1.8v 899.505n 1.8v 909.495n 1.8v 909.505n 1.8v 919.495n 1.8v 919.505n 0.0v 929.495n 0.0v 929.505n 0.0v 939.495n 0.0v 939.505n 0.0v 949.495n 0.0v 949.505n 0.0v 959.495n 0.0v 959.505n 0.0v 969.495n 0.0v 969.505n 1.8v 979.495n 1.8v 979.505n 1.8v 989.495n 1.8v 989.505n 1.8v 999.495n 1.8v 999.505n 0.0v 1009.495n 0.0v 1009.505n 0.0v 1019.495n 0.0v 1019.505n 1.8v 1029.495n 1.8v 1029.505n 1.8v 1039.495n 1.8v 1039.505n 1.8v 1049.495n 1.8v 1049.505n 1.8v 1059.495n 1.8v 1059.505n 1.8v 1069.495n 1.8v 1069.505n 1.8v 1079.495n 1.8v 1079.505n 1.8v 1089.495n 1.8v 1089.505n 1.8v 1099.495n 1.8v 1099.505n 1.8v 1109.495n 1.8v 1109.505n 1.8v 1119.495n 1.8v 1119.505n 0.0v 1129.495n 0.0v 1129.505n 0.0v 1139.495n 0.0v 1139.505n 1.8v 1149.495n 1.8v 1149.505n 1.8v 1159.495n 1.8v 1159.505n 0.0v 1169.495n 0.0v 1169.505n 1.8v 1179.495n 1.8v 1179.505n 1.8v 1189.495n 1.8v 1189.505n 1.8v 1199.495n 1.8v 1199.505n 0.0v 1209.495n 0.0v 1209.505n 0.0v 1219.495n 0.0v 1219.505n 0.0v 1229.495n 0.0v 1229.505n 0.0v 1239.495n 0.0v 1239.505n 0.0v 1249.495n 0.0v 1249.505n 1.8v 1259.495n 1.8v 1259.505n 0.0v 1269.495n 0.0v 1269.505n 1.8v 1279.495n 1.8v 1279.505n 1.8v 1289.495n 1.8v 1289.505n 1.8v 1299.495n 1.8v 1299.505n 1.8v 1309.495n 1.8v 1309.505n 1.8v 1319.495n 1.8v 1319.505n 1.8v 1329.495n 1.8v 1329.505n 1.8v 1339.495n 1.8v 1339.505n 1.8v 1349.495n 1.8v 1349.505n 1.8v 1359.495n 1.8v 1359.505n 1.8v 1369.495n 1.8v 1369.505n 0.0v 1379.495n 0.0v 1379.505n 0.0v 1389.495n 0.0v 1389.505n 0.0v 1399.495n 0.0v 1399.505n 0.0v 1409.495n 0.0v 1409.505n 0.0v 1419.495n 0.0v 1419.505n 0.0v 1429.495n 0.0v 1429.505n 0.0v 1439.495n 0.0v 1439.505n 0.0v 1449.495n 0.0v 1449.505n 0.0v 1459.495n 0.0v 1459.505n 1.8v 1469.495n 1.8v 1469.505n 0.0v 1479.495n 0.0v 1479.505n 0.0v 1489.495n 0.0v 1489.505n 0.0v 1499.495n 0.0v 1499.505n 0.0v 1509.495n 0.0v 1509.505n 0.0v 1519.495n 0.0v 1519.505n 0.0v 1529.495n 0.0v 1529.505n 0.0v 1539.495n 0.0v 1539.505n 0.0v 1549.495n 0.0v 1549.505n 1.8v 1559.495n 1.8v 1559.505n 1.8v 1569.495n 1.8v 1569.505n 1.8v 1579.495n 1.8v 1579.505n 1.8v 1589.495n 1.8v 1589.505n 0.0v 1599.495n 0.0v 1599.505n 0.0v 1609.495n 0.0v 1609.505n 0.0v 1619.495n 0.0v 1619.505n 0.0v 1629.495n 0.0v 1629.505n 0.0v 1639.495n 0.0v 1639.505n 0.0v 1649.495n 0.0v 1649.505n 0.0v 1659.495n 0.0v 1659.505n 0.0v 1669.495n 0.0v 1669.505n 0.0v 1679.495n 0.0v 1679.505n 0.0v 1689.495n 0.0v 1689.505n 0.0v 1699.495n 0.0v 1699.505n 0.0v 1709.495n 0.0v 1709.505n 0.0v 1719.495n 0.0v 1719.505n 1.8v 1729.495n 1.8v 1729.505n 1.8v 1739.495n 1.8v 1739.505n 1.8v 1749.495n 1.8v 1749.505n 1.8v 1759.495n 1.8v 1759.505n 1.8v 1769.495n 1.8v 1769.505n 1.8v 1779.495n 1.8v 1779.505n 0.0v 1789.495n 0.0v 1789.505n 1.8v 1799.495n 1.8v 1799.505n 0.0v 1809.495n 0.0v 1809.505n 0.0v 1819.495n 0.0v 1819.505n 0.0v 1829.495n 0.0v 1829.505n 0.0v 1839.495n 0.0v 1839.505n 0.0v 1849.495n 0.0v 1849.505n 0.0v 1859.495n 0.0v 1859.505n 0.0v 1869.495n 0.0v 1869.505n 0.0v 1879.495n 0.0v 1879.505n 0.0v 1889.495n 0.0v 1889.505n 0.0v 1899.495n 0.0v 1899.505n 0.0v 1909.495n 0.0v 1909.505n 1.8v 1919.495n 1.8v 1919.505n 1.8v 1929.495n 1.8v 1929.505n 0.0v 1939.495n 0.0v 1939.505n 0.0v 1949.495n 0.0v 1949.505n 0.0v 1959.495n 0.0v 1959.505n 0.0v 1969.495n 0.0v 1969.505n 0.0v 1979.495n 0.0v 1979.505n 1.8v 1989.495n 1.8v 1989.505n 1.8v 1999.495n 1.8v 1999.505n 1.8v 2009.495n 1.8v 2009.505n 1.8v 2019.495n 1.8v 2019.505n 1.8v 2029.495n 1.8v 2029.505n 1.8v 2039.495n 1.8v 2039.505n 1.8v 2049.495n 1.8v 2049.505n 1.8v )
* (time, data): [(0, 0), (10, 0), (20, 0), (30, 0), (40, 0), (50, 0), (60, 1), (70, 1), (80, 1), (90, 1), (100, 1), (110, 1), (120, 1), (130, 1), (140, 1), (150, 1), (160, 1), (170, 1), (180, 1), (190, 1), (200, 1), (210, 1), (220, 1), (230, 1), (240, 1), (250, 1), (260, 1), (270, 1), (280, 1), (290, 1), (300, 1), (310, 1), (320, 0), (330, 0), (340, 0), (350, 0), (360, 0), (370, 0), (380, 0), (390, 0), (400, 0), (410, 1), (420, 1), (430, 1), (440, 0), (450, 0), (460, 0), (470, 0), (480, 0), (490, 1), (500, 1), (510, 0), (520, 0), (530, 0), (540, 0), (550, 1), (560, 1), (570, 1), (580, 1), (590, 0), (600, 0), (610, 0), (620, 0), (630, 0), (640, 0), (650, 0), (660, 1), (670, 0), (680, 0), (690, 0), (700, 0), (710, 0), (720, 0), (730, 0), (740, 0), (750, 0), (760, 0), (770, 0), (780, 0), (790, 0), (800, 1), (810, 1), (820, 1), (830, 1), (840, 1), (850, 1), (860, 1), (870, 1), (880, 1), (890, 1), (900, 1), (910, 1), (920, 0), (930, 0), (940, 0), (950, 0), (960, 0), (970, 1), (980, 0), (990, 0), (1000, 0), (1010, 0), (1020, 1), (1030, 1), (1040, 1), (1050, 1), (1060, 1), (1070, 1), (1080, 1), (1090, 1), (1100, 1), (1110, 1), (1120, 0), (1130, 0), (1140, 0), (1150, 0), (1160, 0), (1170, 1), (1180, 1), (1190, 1), (1200, 1), (1210, 1), (1220, 1), (1230, 0), (1240, 1), (1250, 1), (1260, 0), (1270, 1), (1280, 1), (1290, 1), (1300, 1), (1310, 1), (1320, 0), (1330, 0), (1340, 0), (1350, 1), (1360, 0), (1370, 0), (1380, 0), (1390, 0), (1400, 0), (1410, 0), (1420, 0), (1430, 0), (1440, 0), (1450, 0), (1460, 0), (1470, 1), (1480, 1), (1490, 1), (1500, 1), (1510, 1), (1520, 1), (1530, 1), (1540, 1), (1550, 1), (1560, 0), (1570, 0), (1580, 0), (1590, 1), (1600, 1), (1610, 1), (1620, 1), (1630, 1), (1640, 1), (1650, 1), (1660, 1), (1670, 1), (1680, 1), (1690, 1), (1700, 1), (1710, 1), (1720, 1), (1730, 1), (1740, 1), (1750, 1), (1760, 1), (1770, 1), (1780, 0), (1790, 0), (1800, 0), (1810, 1), (1820, 1), (1830, 1), (1840, 1), (1850, 1), (1860, 1), (1870, 1), (1880, 0), (1890, 0), (1900, 0), (1910, 1), (1920, 1), (1930, 1), (1940, 1), (1950, 1), (1960, 1), (1970, 1), (1980, 1), (1990, 1), (2000, 1), (2010, 0), (2020, 0), (2030, 0), (2040, 0), (2050, 0)]
Vdin0_10  din0_10  0 PWL (0n 0.0v 9.495n 0.0v 9.505n 0.0v 19.495n 0.0v 19.505n 0.0v 29.495n 0.0v 29.505n 0.0v 39.495n 0.0v 39.505n 0.0v 49.495n 0.0v 49.505n 0.0v 59.495n 0.0v 59.505n 1.8v 69.495n 1.8v 69.505n 1.8v 79.495n 1.8v 79.505n 1.8v 89.495n 1.8v 89.505n 1.8v 99.495n 1.8v 99.505n 1.8v 109.495n 1.8v 109.505n 1.8v 119.495n 1.8v 119.505n 1.8v 129.495n 1.8v 129.505n 1.8v 139.495n 1.8v 139.505n 1.8v 149.495n 1.8v 149.505n 1.8v 159.495n 1.8v 159.505n 1.8v 169.495n 1.8v 169.505n 1.8v 179.495n 1.8v 179.505n 1.8v 189.495n 1.8v 189.505n 1.8v 199.495n 1.8v 199.505n 1.8v 209.495n 1.8v 209.505n 1.8v 219.495n 1.8v 219.505n 1.8v 229.495n 1.8v 229.505n 1.8v 239.495n 1.8v 239.505n 1.8v 249.495n 1.8v 249.505n 1.8v 259.495n 1.8v 259.505n 1.8v 269.495n 1.8v 269.505n 1.8v 279.495n 1.8v 279.505n 1.8v 289.495n 1.8v 289.505n 1.8v 299.495n 1.8v 299.505n 1.8v 309.495n 1.8v 309.505n 1.8v 319.495n 1.8v 319.505n 0.0v 329.495n 0.0v 329.505n 0.0v 339.495n 0.0v 339.505n 0.0v 349.495n 0.0v 349.505n 0.0v 359.495n 0.0v 359.505n 0.0v 369.495n 0.0v 369.505n 0.0v 379.495n 0.0v 379.505n 0.0v 389.495n 0.0v 389.505n 0.0v 399.495n 0.0v 399.505n 0.0v 409.495n 0.0v 409.505n 1.8v 419.495n 1.8v 419.505n 1.8v 429.495n 1.8v 429.505n 1.8v 439.495n 1.8v 439.505n 0.0v 449.495n 0.0v 449.505n 0.0v 459.495n 0.0v 459.505n 0.0v 469.495n 0.0v 469.505n 0.0v 479.495n 0.0v 479.505n 0.0v 489.495n 0.0v 489.505n 1.8v 499.495n 1.8v 499.505n 1.8v 509.495n 1.8v 509.505n 0.0v 519.495n 0.0v 519.505n 0.0v 529.495n 0.0v 529.505n 0.0v 539.495n 0.0v 539.505n 0.0v 549.495n 0.0v 549.505n 1.8v 559.495n 1.8v 559.505n 1.8v 569.495n 1.8v 569.505n 1.8v 579.495n 1.8v 579.505n 1.8v 589.495n 1.8v 589.505n 0.0v 599.495n 0.0v 599.505n 0.0v 609.495n 0.0v 609.505n 0.0v 619.495n 0.0v 619.505n 0.0v 629.495n 0.0v 629.505n 0.0v 639.495n 0.0v 639.505n 0.0v 649.495n 0.0v 649.505n 0.0v 659.495n 0.0v 659.505n 1.8v 669.495n 1.8v 669.505n 0.0v 679.495n 0.0v 679.505n 0.0v 689.495n 0.0v 689.505n 0.0v 699.495n 0.0v 699.505n 0.0v 709.495n 0.0v 709.505n 0.0v 719.495n 0.0v 719.505n 0.0v 729.495n 0.0v 729.505n 0.0v 739.495n 0.0v 739.505n 0.0v 749.495n 0.0v 749.505n 0.0v 759.495n 0.0v 759.505n 0.0v 769.495n 0.0v 769.505n 0.0v 779.495n 0.0v 779.505n 0.0v 789.495n 0.0v 789.505n 0.0v 799.495n 0.0v 799.505n 1.8v 809.495n 1.8v 809.505n 1.8v 819.495n 1.8v 819.505n 1.8v 829.495n 1.8v 829.505n 1.8v 839.495n 1.8v 839.505n 1.8v 849.495n 1.8v 849.505n 1.8v 859.495n 1.8v 859.505n 1.8v 869.495n 1.8v 869.505n 1.8v 879.495n 1.8v 879.505n 1.8v 889.495n 1.8v 889.505n 1.8v 899.495n 1.8v 899.505n 1.8v 909.495n 1.8v 909.505n 1.8v 919.495n 1.8v 919.505n 0.0v 929.495n 0.0v 929.505n 0.0v 939.495n 0.0v 939.505n 0.0v 949.495n 0.0v 949.505n 0.0v 959.495n 0.0v 959.505n 0.0v 969.495n 0.0v 969.505n 1.8v 979.495n 1.8v 979.505n 0.0v 989.495n 0.0v 989.505n 0.0v 999.495n 0.0v 999.505n 0.0v 1009.495n 0.0v 1009.505n 0.0v 1019.495n 0.0v 1019.505n 1.8v 1029.495n 1.8v 1029.505n 1.8v 1039.495n 1.8v 1039.505n 1.8v 1049.495n 1.8v 1049.505n 1.8v 1059.495n 1.8v 1059.505n 1.8v 1069.495n 1.8v 1069.505n 1.8v 1079.495n 1.8v 1079.505n 1.8v 1089.495n 1.8v 1089.505n 1.8v 1099.495n 1.8v 1099.505n 1.8v 1109.495n 1.8v 1109.505n 1.8v 1119.495n 1.8v 1119.505n 0.0v 1129.495n 0.0v 1129.505n 0.0v 1139.495n 0.0v 1139.505n 0.0v 1149.495n 0.0v 1149.505n 0.0v 1159.495n 0.0v 1159.505n 0.0v 1169.495n 0.0v 1169.505n 1.8v 1179.495n 1.8v 1179.505n 1.8v 1189.495n 1.8v 1189.505n 1.8v 1199.495n 1.8v 1199.505n 1.8v 1209.495n 1.8v 1209.505n 1.8v 1219.495n 1.8v 1219.505n 1.8v 1229.495n 1.8v 1229.505n 0.0v 1239.495n 0.0v 1239.505n 1.8v 1249.495n 1.8v 1249.505n 1.8v 1259.495n 1.8v 1259.505n 0.0v 1269.495n 0.0v 1269.505n 1.8v 1279.495n 1.8v 1279.505n 1.8v 1289.495n 1.8v 1289.505n 1.8v 1299.495n 1.8v 1299.505n 1.8v 1309.495n 1.8v 1309.505n 1.8v 1319.495n 1.8v 1319.505n 0.0v 1329.495n 0.0v 1329.505n 0.0v 1339.495n 0.0v 1339.505n 0.0v 1349.495n 0.0v 1349.505n 1.8v 1359.495n 1.8v 1359.505n 0.0v 1369.495n 0.0v 1369.505n 0.0v 1379.495n 0.0v 1379.505n 0.0v 1389.495n 0.0v 1389.505n 0.0v 1399.495n 0.0v 1399.505n 0.0v 1409.495n 0.0v 1409.505n 0.0v 1419.495n 0.0v 1419.505n 0.0v 1429.495n 0.0v 1429.505n 0.0v 1439.495n 0.0v 1439.505n 0.0v 1449.495n 0.0v 1449.505n 0.0v 1459.495n 0.0v 1459.505n 0.0v 1469.495n 0.0v 1469.505n 1.8v 1479.495n 1.8v 1479.505n 1.8v 1489.495n 1.8v 1489.505n 1.8v 1499.495n 1.8v 1499.505n 1.8v 1509.495n 1.8v 1509.505n 1.8v 1519.495n 1.8v 1519.505n 1.8v 1529.495n 1.8v 1529.505n 1.8v 1539.495n 1.8v 1539.505n 1.8v 1549.495n 1.8v 1549.505n 1.8v 1559.495n 1.8v 1559.505n 0.0v 1569.495n 0.0v 1569.505n 0.0v 1579.495n 0.0v 1579.505n 0.0v 1589.495n 0.0v 1589.505n 1.8v 1599.495n 1.8v 1599.505n 1.8v 1609.495n 1.8v 1609.505n 1.8v 1619.495n 1.8v 1619.505n 1.8v 1629.495n 1.8v 1629.505n 1.8v 1639.495n 1.8v 1639.505n 1.8v 1649.495n 1.8v 1649.505n 1.8v 1659.495n 1.8v 1659.505n 1.8v 1669.495n 1.8v 1669.505n 1.8v 1679.495n 1.8v 1679.505n 1.8v 1689.495n 1.8v 1689.505n 1.8v 1699.495n 1.8v 1699.505n 1.8v 1709.495n 1.8v 1709.505n 1.8v 1719.495n 1.8v 1719.505n 1.8v 1729.495n 1.8v 1729.505n 1.8v 1739.495n 1.8v 1739.505n 1.8v 1749.495n 1.8v 1749.505n 1.8v 1759.495n 1.8v 1759.505n 1.8v 1769.495n 1.8v 1769.505n 1.8v 1779.495n 1.8v 1779.505n 0.0v 1789.495n 0.0v 1789.505n 0.0v 1799.495n 0.0v 1799.505n 0.0v 1809.495n 0.0v 1809.505n 1.8v 1819.495n 1.8v 1819.505n 1.8v 1829.495n 1.8v 1829.505n 1.8v 1839.495n 1.8v 1839.505n 1.8v 1849.495n 1.8v 1849.505n 1.8v 1859.495n 1.8v 1859.505n 1.8v 1869.495n 1.8v 1869.505n 1.8v 1879.495n 1.8v 1879.505n 0.0v 1889.495n 0.0v 1889.505n 0.0v 1899.495n 0.0v 1899.505n 0.0v 1909.495n 0.0v 1909.505n 1.8v 1919.495n 1.8v 1919.505n 1.8v 1929.495n 1.8v 1929.505n 1.8v 1939.495n 1.8v 1939.505n 1.8v 1949.495n 1.8v 1949.505n 1.8v 1959.495n 1.8v 1959.505n 1.8v 1969.495n 1.8v 1969.505n 1.8v 1979.495n 1.8v 1979.505n 1.8v 1989.495n 1.8v 1989.505n 1.8v 1999.495n 1.8v 1999.505n 1.8v 2009.495n 1.8v 2009.505n 0.0v 2019.495n 0.0v 2019.505n 0.0v 2029.495n 0.0v 2029.505n 0.0v 2039.495n 0.0v 2039.505n 0.0v 2049.495n 0.0v 2049.505n 0.0v )
* (time, data): [(0, 0), (10, 0), (20, 1), (30, 0), (40, 0), (50, 0), (60, 0), (70, 0), (80, 0), (90, 0), (100, 0), (110, 0), (120, 0), (130, 0), (140, 0), (150, 0), (160, 0), (170, 0), (180, 0), (190, 0), (200, 1), (210, 1), (220, 1), (230, 1), (240, 1), (250, 1), (260, 1), (270, 1), (280, 1), (290, 1), (300, 1), (310, 1), (320, 0), (330, 0), (340, 0), (350, 0), (360, 0), (370, 0), (380, 1), (390, 1), (400, 1), (410, 1), (420, 0), (430, 0), (440, 0), (450, 0), (460, 0), (470, 0), (480, 0), (490, 1), (500, 1), (510, 1), (520, 1), (530, 1), (540, 1), (550, 1), (560, 1), (570, 1), (580, 0), (590, 1), (600, 1), (610, 1), (620, 1), (630, 0), (640, 0), (650, 0), (660, 0), (670, 0), (680, 0), (690, 0), (700, 1), (710, 1), (720, 1), (730, 0), (740, 0), (750, 0), (760, 1), (770, 0), (780, 1), (790, 1), (800, 0), (810, 0), (820, 0), (830, 0), (840, 1), (850, 1), (860, 1), (870, 0), (880, 0), (890, 0), (900, 0), (910, 0), (920, 1), (930, 1), (940, 1), (950, 1), (960, 1), (970, 1), (980, 1), (990, 1), (1000, 1), (1010, 1), (1020, 1), (1030, 1), (1040, 1), (1050, 1), (1060, 1), (1070, 1), (1080, 1), (1090, 1), (1100, 1), (1110, 1), (1120, 1), (1130, 1), (1140, 0), (1150, 0), (1160, 1), (1170, 1), (1180, 1), (1190, 1), (1200, 0), (1210, 0), (1220, 0), (1230, 1), (1240, 1), (1250, 1), (1260, 1), (1270, 1), (1280, 1), (1290, 1), (1300, 1), (1310, 1), (1320, 1), (1330, 0), (1340, 0), (1350, 1), (1360, 0), (1370, 0), (1380, 0), (1390, 0), (1400, 0), (1410, 0), (1420, 0), (1430, 0), (1440, 1), (1450, 1), (1460, 0), (1470, 1), (1480, 1), (1490, 1), (1500, 1), (1510, 1), (1520, 1), (1530, 1), (1540, 1), (1550, 1), (1560, 1), (1570, 1), (1580, 1), (1590, 1), (1600, 1), (1610, 1), (1620, 1), (1630, 1), (1640, 1), (1650, 1), (1660, 1), (1670, 1), (1680, 1), (1690, 1), (1700, 1), (1710, 1), (1720, 1), (1730, 1), (1740, 1), (1750, 1), (1760, 1), (1770, 1), (1780, 1), (1790, 1), (1800, 1), (1810, 1), (1820, 1), (1830, 1), (1840, 1), (1850, 1), (1860, 1), (1870, 1), (1880, 1), (1890, 1), (1900, 1), (1910, 0), (1920, 0), (1930, 1), (1940, 1), (1950, 1), (1960, 1), (1970, 1), (1980, 0), (1990, 0), (2000, 0), (2010, 1), (2020, 1), (2030, 1), (2040, 1), (2050, 1)]
Vdin0_11  din0_11  0 PWL (0n 0.0v 9.495n 0.0v 9.505n 0.0v 19.495n 0.0v 19.505n 1.8v 29.495n 1.8v 29.505n 0.0v 39.495n 0.0v 39.505n 0.0v 49.495n 0.0v 49.505n 0.0v 59.495n 0.0v 59.505n 0.0v 69.495n 0.0v 69.505n 0.0v 79.495n 0.0v 79.505n 0.0v 89.495n 0.0v 89.505n 0.0v 99.495n 0.0v 99.505n 0.0v 109.495n 0.0v 109.505n 0.0v 119.495n 0.0v 119.505n 0.0v 129.495n 0.0v 129.505n 0.0v 139.495n 0.0v 139.505n 0.0v 149.495n 0.0v 149.505n 0.0v 159.495n 0.0v 159.505n 0.0v 169.495n 0.0v 169.505n 0.0v 179.495n 0.0v 179.505n 0.0v 189.495n 0.0v 189.505n 0.0v 199.495n 0.0v 199.505n 1.8v 209.495n 1.8v 209.505n 1.8v 219.495n 1.8v 219.505n 1.8v 229.495n 1.8v 229.505n 1.8v 239.495n 1.8v 239.505n 1.8v 249.495n 1.8v 249.505n 1.8v 259.495n 1.8v 259.505n 1.8v 269.495n 1.8v 269.505n 1.8v 279.495n 1.8v 279.505n 1.8v 289.495n 1.8v 289.505n 1.8v 299.495n 1.8v 299.505n 1.8v 309.495n 1.8v 309.505n 1.8v 319.495n 1.8v 319.505n 0.0v 329.495n 0.0v 329.505n 0.0v 339.495n 0.0v 339.505n 0.0v 349.495n 0.0v 349.505n 0.0v 359.495n 0.0v 359.505n 0.0v 369.495n 0.0v 369.505n 0.0v 379.495n 0.0v 379.505n 1.8v 389.495n 1.8v 389.505n 1.8v 399.495n 1.8v 399.505n 1.8v 409.495n 1.8v 409.505n 1.8v 419.495n 1.8v 419.505n 0.0v 429.495n 0.0v 429.505n 0.0v 439.495n 0.0v 439.505n 0.0v 449.495n 0.0v 449.505n 0.0v 459.495n 0.0v 459.505n 0.0v 469.495n 0.0v 469.505n 0.0v 479.495n 0.0v 479.505n 0.0v 489.495n 0.0v 489.505n 1.8v 499.495n 1.8v 499.505n 1.8v 509.495n 1.8v 509.505n 1.8v 519.495n 1.8v 519.505n 1.8v 529.495n 1.8v 529.505n 1.8v 539.495n 1.8v 539.505n 1.8v 549.495n 1.8v 549.505n 1.8v 559.495n 1.8v 559.505n 1.8v 569.495n 1.8v 569.505n 1.8v 579.495n 1.8v 579.505n 0.0v 589.495n 0.0v 589.505n 1.8v 599.495n 1.8v 599.505n 1.8v 609.495n 1.8v 609.505n 1.8v 619.495n 1.8v 619.505n 1.8v 629.495n 1.8v 629.505n 0.0v 639.495n 0.0v 639.505n 0.0v 649.495n 0.0v 649.505n 0.0v 659.495n 0.0v 659.505n 0.0v 669.495n 0.0v 669.505n 0.0v 679.495n 0.0v 679.505n 0.0v 689.495n 0.0v 689.505n 0.0v 699.495n 0.0v 699.505n 1.8v 709.495n 1.8v 709.505n 1.8v 719.495n 1.8v 719.505n 1.8v 729.495n 1.8v 729.505n 0.0v 739.495n 0.0v 739.505n 0.0v 749.495n 0.0v 749.505n 0.0v 759.495n 0.0v 759.505n 1.8v 769.495n 1.8v 769.505n 0.0v 779.495n 0.0v 779.505n 1.8v 789.495n 1.8v 789.505n 1.8v 799.495n 1.8v 799.505n 0.0v 809.495n 0.0v 809.505n 0.0v 819.495n 0.0v 819.505n 0.0v 829.495n 0.0v 829.505n 0.0v 839.495n 0.0v 839.505n 1.8v 849.495n 1.8v 849.505n 1.8v 859.495n 1.8v 859.505n 1.8v 869.495n 1.8v 869.505n 0.0v 879.495n 0.0v 879.505n 0.0v 889.495n 0.0v 889.505n 0.0v 899.495n 0.0v 899.505n 0.0v 909.495n 0.0v 909.505n 0.0v 919.495n 0.0v 919.505n 1.8v 929.495n 1.8v 929.505n 1.8v 939.495n 1.8v 939.505n 1.8v 949.495n 1.8v 949.505n 1.8v 959.495n 1.8v 959.505n 1.8v 969.495n 1.8v 969.505n 1.8v 979.495n 1.8v 979.505n 1.8v 989.495n 1.8v 989.505n 1.8v 999.495n 1.8v 999.505n 1.8v 1009.495n 1.8v 1009.505n 1.8v 1019.495n 1.8v 1019.505n 1.8v 1029.495n 1.8v 1029.505n 1.8v 1039.495n 1.8v 1039.505n 1.8v 1049.495n 1.8v 1049.505n 1.8v 1059.495n 1.8v 1059.505n 1.8v 1069.495n 1.8v 1069.505n 1.8v 1079.495n 1.8v 1079.505n 1.8v 1089.495n 1.8v 1089.505n 1.8v 1099.495n 1.8v 1099.505n 1.8v 1109.495n 1.8v 1109.505n 1.8v 1119.495n 1.8v 1119.505n 1.8v 1129.495n 1.8v 1129.505n 1.8v 1139.495n 1.8v 1139.505n 0.0v 1149.495n 0.0v 1149.505n 0.0v 1159.495n 0.0v 1159.505n 1.8v 1169.495n 1.8v 1169.505n 1.8v 1179.495n 1.8v 1179.505n 1.8v 1189.495n 1.8v 1189.505n 1.8v 1199.495n 1.8v 1199.505n 0.0v 1209.495n 0.0v 1209.505n 0.0v 1219.495n 0.0v 1219.505n 0.0v 1229.495n 0.0v 1229.505n 1.8v 1239.495n 1.8v 1239.505n 1.8v 1249.495n 1.8v 1249.505n 1.8v 1259.495n 1.8v 1259.505n 1.8v 1269.495n 1.8v 1269.505n 1.8v 1279.495n 1.8v 1279.505n 1.8v 1289.495n 1.8v 1289.505n 1.8v 1299.495n 1.8v 1299.505n 1.8v 1309.495n 1.8v 1309.505n 1.8v 1319.495n 1.8v 1319.505n 1.8v 1329.495n 1.8v 1329.505n 0.0v 1339.495n 0.0v 1339.505n 0.0v 1349.495n 0.0v 1349.505n 1.8v 1359.495n 1.8v 1359.505n 0.0v 1369.495n 0.0v 1369.505n 0.0v 1379.495n 0.0v 1379.505n 0.0v 1389.495n 0.0v 1389.505n 0.0v 1399.495n 0.0v 1399.505n 0.0v 1409.495n 0.0v 1409.505n 0.0v 1419.495n 0.0v 1419.505n 0.0v 1429.495n 0.0v 1429.505n 0.0v 1439.495n 0.0v 1439.505n 1.8v 1449.495n 1.8v 1449.505n 1.8v 1459.495n 1.8v 1459.505n 0.0v 1469.495n 0.0v 1469.505n 1.8v 1479.495n 1.8v 1479.505n 1.8v 1489.495n 1.8v 1489.505n 1.8v 1499.495n 1.8v 1499.505n 1.8v 1509.495n 1.8v 1509.505n 1.8v 1519.495n 1.8v 1519.505n 1.8v 1529.495n 1.8v 1529.505n 1.8v 1539.495n 1.8v 1539.505n 1.8v 1549.495n 1.8v 1549.505n 1.8v 1559.495n 1.8v 1559.505n 1.8v 1569.495n 1.8v 1569.505n 1.8v 1579.495n 1.8v 1579.505n 1.8v 1589.495n 1.8v 1589.505n 1.8v 1599.495n 1.8v 1599.505n 1.8v 1609.495n 1.8v 1609.505n 1.8v 1619.495n 1.8v 1619.505n 1.8v 1629.495n 1.8v 1629.505n 1.8v 1639.495n 1.8v 1639.505n 1.8v 1649.495n 1.8v 1649.505n 1.8v 1659.495n 1.8v 1659.505n 1.8v 1669.495n 1.8v 1669.505n 1.8v 1679.495n 1.8v 1679.505n 1.8v 1689.495n 1.8v 1689.505n 1.8v 1699.495n 1.8v 1699.505n 1.8v 1709.495n 1.8v 1709.505n 1.8v 1719.495n 1.8v 1719.505n 1.8v 1729.495n 1.8v 1729.505n 1.8v 1739.495n 1.8v 1739.505n 1.8v 1749.495n 1.8v 1749.505n 1.8v 1759.495n 1.8v 1759.505n 1.8v 1769.495n 1.8v 1769.505n 1.8v 1779.495n 1.8v 1779.505n 1.8v 1789.495n 1.8v 1789.505n 1.8v 1799.495n 1.8v 1799.505n 1.8v 1809.495n 1.8v 1809.505n 1.8v 1819.495n 1.8v 1819.505n 1.8v 1829.495n 1.8v 1829.505n 1.8v 1839.495n 1.8v 1839.505n 1.8v 1849.495n 1.8v 1849.505n 1.8v 1859.495n 1.8v 1859.505n 1.8v 1869.495n 1.8v 1869.505n 1.8v 1879.495n 1.8v 1879.505n 1.8v 1889.495n 1.8v 1889.505n 1.8v 1899.495n 1.8v 1899.505n 1.8v 1909.495n 1.8v 1909.505n 0.0v 1919.495n 0.0v 1919.505n 0.0v 1929.495n 0.0v 1929.505n 1.8v 1939.495n 1.8v 1939.505n 1.8v 1949.495n 1.8v 1949.505n 1.8v 1959.495n 1.8v 1959.505n 1.8v 1969.495n 1.8v 1969.505n 1.8v 1979.495n 1.8v 1979.505n 0.0v 1989.495n 0.0v 1989.505n 0.0v 1999.495n 0.0v 1999.505n 0.0v 2009.495n 0.0v 2009.505n 1.8v 2019.495n 1.8v 2019.505n 1.8v 2029.495n 1.8v 2029.505n 1.8v 2039.495n 1.8v 2039.505n 1.8v 2049.495n 1.8v 2049.505n 1.8v )
* (time, data): [(0, 0), (10, 1), (20, 0), (30, 1), (40, 1), (50, 1), (60, 1), (70, 1), (80, 1), (90, 0), (100, 0), (110, 0), (120, 1), (130, 1), (140, 1), (150, 1), (160, 1), (170, 1), (180, 1), (190, 1), (200, 0), (210, 0), (220, 0), (230, 0), (240, 0), (250, 1), (260, 1), (270, 1), (280, 1), (290, 1), (300, 1), (310, 1), (320, 1), (330, 1), (340, 1), (350, 1), (360, 0), (370, 0), (380, 0), (390, 0), (400, 0), (410, 0), (420, 1), (430, 1), (440, 1), (450, 1), (460, 1), (470, 1), (480, 1), (490, 1), (500, 1), (510, 1), (520, 1), (530, 0), (540, 0), (550, 1), (560, 1), (570, 1), (580, 1), (590, 0), (600, 0), (610, 0), (620, 0), (630, 1), (640, 1), (650, 1), (660, 1), (670, 0), (680, 0), (690, 0), (700, 0), (710, 0), (720, 0), (730, 0), (740, 1), (750, 1), (760, 1), (770, 0), (780, 1), (790, 1), (800, 1), (810, 1), (820, 1), (830, 1), (840, 0), (850, 0), (860, 0), (870, 1), (880, 1), (890, 1), (900, 1), (910, 1), (920, 0), (930, 0), (940, 0), (950, 0), (960, 0), (970, 1), (980, 0), (990, 0), (1000, 1), (1010, 1), (1020, 1), (1030, 1), (1040, 1), (1050, 1), (1060, 1), (1070, 1), (1080, 1), (1090, 1), (1100, 1), (1110, 1), (1120, 0), (1130, 0), (1140, 1), (1150, 1), (1160, 1), (1170, 1), (1180, 1), (1190, 1), (1200, 0), (1210, 0), (1220, 0), (1230, 1), (1240, 0), (1250, 0), (1260, 1), (1270, 0), (1280, 0), (1290, 0), (1300, 0), (1310, 0), (1320, 1), (1330, 0), (1340, 1), (1350, 0), (1360, 0), (1370, 1), (1380, 1), (1390, 1), (1400, 1), (1410, 1), (1420, 1), (1430, 1), (1440, 1), (1450, 1), (1460, 1), (1470, 1), (1480, 1), (1490, 1), (1500, 1), (1510, 1), (1520, 1), (1530, 1), (1540, 1), (1550, 0), (1560, 0), (1570, 0), (1580, 0), (1590, 1), (1600, 1), (1610, 1), (1620, 1), (1630, 1), (1640, 0), (1650, 0), (1660, 0), (1670, 0), (1680, 0), (1690, 0), (1700, 0), (1710, 0), (1720, 0), (1730, 0), (1740, 0), (1750, 0), (1760, 0), (1770, 1), (1780, 0), (1790, 0), (1800, 1), (1810, 0), (1820, 0), (1830, 0), (1840, 0), (1850, 0), (1860, 0), (1870, 0), (1880, 1), (1890, 1), (1900, 1), (1910, 0), (1920, 0), (1930, 1), (1940, 1), (1950, 1), (1960, 1), (1970, 1), (1980, 1), (1990, 1), (2000, 1), (2010, 0), (2020, 0), (2030, 0), (2040, 0), (2050, 0)]
Vdin0_12  din0_12  0 PWL (0n 0.0v 9.495n 0.0v 9.505n 1.8v 19.495n 1.8v 19.505n 0.0v 29.495n 0.0v 29.505n 1.8v 39.495n 1.8v 39.505n 1.8v 49.495n 1.8v 49.505n 1.8v 59.495n 1.8v 59.505n 1.8v 69.495n 1.8v 69.505n 1.8v 79.495n 1.8v 79.505n 1.8v 89.495n 1.8v 89.505n 0.0v 99.495n 0.0v 99.505n 0.0v 109.495n 0.0v 109.505n 0.0v 119.495n 0.0v 119.505n 1.8v 129.495n 1.8v 129.505n 1.8v 139.495n 1.8v 139.505n 1.8v 149.495n 1.8v 149.505n 1.8v 159.495n 1.8v 159.505n 1.8v 169.495n 1.8v 169.505n 1.8v 179.495n 1.8v 179.505n 1.8v 189.495n 1.8v 189.505n 1.8v 199.495n 1.8v 199.505n 0.0v 209.495n 0.0v 209.505n 0.0v 219.495n 0.0v 219.505n 0.0v 229.495n 0.0v 229.505n 0.0v 239.495n 0.0v 239.505n 0.0v 249.495n 0.0v 249.505n 1.8v 259.495n 1.8v 259.505n 1.8v 269.495n 1.8v 269.505n 1.8v 279.495n 1.8v 279.505n 1.8v 289.495n 1.8v 289.505n 1.8v 299.495n 1.8v 299.505n 1.8v 309.495n 1.8v 309.505n 1.8v 319.495n 1.8v 319.505n 1.8v 329.495n 1.8v 329.505n 1.8v 339.495n 1.8v 339.505n 1.8v 349.495n 1.8v 349.505n 1.8v 359.495n 1.8v 359.505n 0.0v 369.495n 0.0v 369.505n 0.0v 379.495n 0.0v 379.505n 0.0v 389.495n 0.0v 389.505n 0.0v 399.495n 0.0v 399.505n 0.0v 409.495n 0.0v 409.505n 0.0v 419.495n 0.0v 419.505n 1.8v 429.495n 1.8v 429.505n 1.8v 439.495n 1.8v 439.505n 1.8v 449.495n 1.8v 449.505n 1.8v 459.495n 1.8v 459.505n 1.8v 469.495n 1.8v 469.505n 1.8v 479.495n 1.8v 479.505n 1.8v 489.495n 1.8v 489.505n 1.8v 499.495n 1.8v 499.505n 1.8v 509.495n 1.8v 509.505n 1.8v 519.495n 1.8v 519.505n 1.8v 529.495n 1.8v 529.505n 0.0v 539.495n 0.0v 539.505n 0.0v 549.495n 0.0v 549.505n 1.8v 559.495n 1.8v 559.505n 1.8v 569.495n 1.8v 569.505n 1.8v 579.495n 1.8v 579.505n 1.8v 589.495n 1.8v 589.505n 0.0v 599.495n 0.0v 599.505n 0.0v 609.495n 0.0v 609.505n 0.0v 619.495n 0.0v 619.505n 0.0v 629.495n 0.0v 629.505n 1.8v 639.495n 1.8v 639.505n 1.8v 649.495n 1.8v 649.505n 1.8v 659.495n 1.8v 659.505n 1.8v 669.495n 1.8v 669.505n 0.0v 679.495n 0.0v 679.505n 0.0v 689.495n 0.0v 689.505n 0.0v 699.495n 0.0v 699.505n 0.0v 709.495n 0.0v 709.505n 0.0v 719.495n 0.0v 719.505n 0.0v 729.495n 0.0v 729.505n 0.0v 739.495n 0.0v 739.505n 1.8v 749.495n 1.8v 749.505n 1.8v 759.495n 1.8v 759.505n 1.8v 769.495n 1.8v 769.505n 0.0v 779.495n 0.0v 779.505n 1.8v 789.495n 1.8v 789.505n 1.8v 799.495n 1.8v 799.505n 1.8v 809.495n 1.8v 809.505n 1.8v 819.495n 1.8v 819.505n 1.8v 829.495n 1.8v 829.505n 1.8v 839.495n 1.8v 839.505n 0.0v 849.495n 0.0v 849.505n 0.0v 859.495n 0.0v 859.505n 0.0v 869.495n 0.0v 869.505n 1.8v 879.495n 1.8v 879.505n 1.8v 889.495n 1.8v 889.505n 1.8v 899.495n 1.8v 899.505n 1.8v 909.495n 1.8v 909.505n 1.8v 919.495n 1.8v 919.505n 0.0v 929.495n 0.0v 929.505n 0.0v 939.495n 0.0v 939.505n 0.0v 949.495n 0.0v 949.505n 0.0v 959.495n 0.0v 959.505n 0.0v 969.495n 0.0v 969.505n 1.8v 979.495n 1.8v 979.505n 0.0v 989.495n 0.0v 989.505n 0.0v 999.495n 0.0v 999.505n 1.8v 1009.495n 1.8v 1009.505n 1.8v 1019.495n 1.8v 1019.505n 1.8v 1029.495n 1.8v 1029.505n 1.8v 1039.495n 1.8v 1039.505n 1.8v 1049.495n 1.8v 1049.505n 1.8v 1059.495n 1.8v 1059.505n 1.8v 1069.495n 1.8v 1069.505n 1.8v 1079.495n 1.8v 1079.505n 1.8v 1089.495n 1.8v 1089.505n 1.8v 1099.495n 1.8v 1099.505n 1.8v 1109.495n 1.8v 1109.505n 1.8v 1119.495n 1.8v 1119.505n 0.0v 1129.495n 0.0v 1129.505n 0.0v 1139.495n 0.0v 1139.505n 1.8v 1149.495n 1.8v 1149.505n 1.8v 1159.495n 1.8v 1159.505n 1.8v 1169.495n 1.8v 1169.505n 1.8v 1179.495n 1.8v 1179.505n 1.8v 1189.495n 1.8v 1189.505n 1.8v 1199.495n 1.8v 1199.505n 0.0v 1209.495n 0.0v 1209.505n 0.0v 1219.495n 0.0v 1219.505n 0.0v 1229.495n 0.0v 1229.505n 1.8v 1239.495n 1.8v 1239.505n 0.0v 1249.495n 0.0v 1249.505n 0.0v 1259.495n 0.0v 1259.505n 1.8v 1269.495n 1.8v 1269.505n 0.0v 1279.495n 0.0v 1279.505n 0.0v 1289.495n 0.0v 1289.505n 0.0v 1299.495n 0.0v 1299.505n 0.0v 1309.495n 0.0v 1309.505n 0.0v 1319.495n 0.0v 1319.505n 1.8v 1329.495n 1.8v 1329.505n 0.0v 1339.495n 0.0v 1339.505n 1.8v 1349.495n 1.8v 1349.505n 0.0v 1359.495n 0.0v 1359.505n 0.0v 1369.495n 0.0v 1369.505n 1.8v 1379.495n 1.8v 1379.505n 1.8v 1389.495n 1.8v 1389.505n 1.8v 1399.495n 1.8v 1399.505n 1.8v 1409.495n 1.8v 1409.505n 1.8v 1419.495n 1.8v 1419.505n 1.8v 1429.495n 1.8v 1429.505n 1.8v 1439.495n 1.8v 1439.505n 1.8v 1449.495n 1.8v 1449.505n 1.8v 1459.495n 1.8v 1459.505n 1.8v 1469.495n 1.8v 1469.505n 1.8v 1479.495n 1.8v 1479.505n 1.8v 1489.495n 1.8v 1489.505n 1.8v 1499.495n 1.8v 1499.505n 1.8v 1509.495n 1.8v 1509.505n 1.8v 1519.495n 1.8v 1519.505n 1.8v 1529.495n 1.8v 1529.505n 1.8v 1539.495n 1.8v 1539.505n 1.8v 1549.495n 1.8v 1549.505n 0.0v 1559.495n 0.0v 1559.505n 0.0v 1569.495n 0.0v 1569.505n 0.0v 1579.495n 0.0v 1579.505n 0.0v 1589.495n 0.0v 1589.505n 1.8v 1599.495n 1.8v 1599.505n 1.8v 1609.495n 1.8v 1609.505n 1.8v 1619.495n 1.8v 1619.505n 1.8v 1629.495n 1.8v 1629.505n 1.8v 1639.495n 1.8v 1639.505n 0.0v 1649.495n 0.0v 1649.505n 0.0v 1659.495n 0.0v 1659.505n 0.0v 1669.495n 0.0v 1669.505n 0.0v 1679.495n 0.0v 1679.505n 0.0v 1689.495n 0.0v 1689.505n 0.0v 1699.495n 0.0v 1699.505n 0.0v 1709.495n 0.0v 1709.505n 0.0v 1719.495n 0.0v 1719.505n 0.0v 1729.495n 0.0v 1729.505n 0.0v 1739.495n 0.0v 1739.505n 0.0v 1749.495n 0.0v 1749.505n 0.0v 1759.495n 0.0v 1759.505n 0.0v 1769.495n 0.0v 1769.505n 1.8v 1779.495n 1.8v 1779.505n 0.0v 1789.495n 0.0v 1789.505n 0.0v 1799.495n 0.0v 1799.505n 1.8v 1809.495n 1.8v 1809.505n 0.0v 1819.495n 0.0v 1819.505n 0.0v 1829.495n 0.0v 1829.505n 0.0v 1839.495n 0.0v 1839.505n 0.0v 1849.495n 0.0v 1849.505n 0.0v 1859.495n 0.0v 1859.505n 0.0v 1869.495n 0.0v 1869.505n 0.0v 1879.495n 0.0v 1879.505n 1.8v 1889.495n 1.8v 1889.505n 1.8v 1899.495n 1.8v 1899.505n 1.8v 1909.495n 1.8v 1909.505n 0.0v 1919.495n 0.0v 1919.505n 0.0v 1929.495n 0.0v 1929.505n 1.8v 1939.495n 1.8v 1939.505n 1.8v 1949.495n 1.8v 1949.505n 1.8v 1959.495n 1.8v 1959.505n 1.8v 1969.495n 1.8v 1969.505n 1.8v 1979.495n 1.8v 1979.505n 1.8v 1989.495n 1.8v 1989.505n 1.8v 1999.495n 1.8v 1999.505n 1.8v 2009.495n 1.8v 2009.505n 0.0v 2019.495n 0.0v 2019.505n 0.0v 2029.495n 0.0v 2029.505n 0.0v 2039.495n 0.0v 2039.505n 0.0v 2049.495n 0.0v 2049.505n 0.0v )
* (time, data): [(0, 0), (10, 1), (20, 1), (30, 1), (40, 1), (50, 1), (60, 0), (70, 0), (80, 0), (90, 0), (100, 0), (110, 0), (120, 1), (130, 1), (140, 1), (150, 1), (160, 1), (170, 1), (180, 1), (190, 1), (200, 0), (210, 0), (220, 0), (230, 0), (240, 0), (250, 0), (260, 0), (270, 0), (280, 0), (290, 0), (300, 0), (310, 0), (320, 0), (330, 0), (340, 0), (350, 0), (360, 1), (370, 1), (380, 1), (390, 1), (400, 1), (410, 0), (420, 0), (430, 0), (440, 0), (450, 0), (460, 0), (470, 0), (480, 0), (490, 0), (500, 0), (510, 1), (520, 1), (530, 0), (540, 1), (550, 1), (560, 1), (570, 1), (580, 0), (590, 0), (600, 0), (610, 0), (620, 0), (630, 1), (640, 1), (650, 1), (660, 1), (670, 1), (680, 1), (690, 1), (700, 0), (710, 0), (720, 0), (730, 0), (740, 1), (750, 1), (760, 0), (770, 1), (780, 0), (790, 0), (800, 0), (810, 0), (820, 0), (830, 0), (840, 1), (850, 1), (860, 1), (870, 0), (880, 0), (890, 0), (900, 0), (910, 0), (920, 0), (930, 0), (940, 0), (950, 0), (960, 0), (970, 0), (980, 1), (990, 1), (1000, 0), (1010, 0), (1020, 1), (1030, 1), (1040, 1), (1050, 1), (1060, 1), (1070, 1), (1080, 1), (1090, 1), (1100, 1), (1110, 1), (1120, 0), (1130, 0), (1140, 1), (1150, 1), (1160, 1), (1170, 1), (1180, 1), (1190, 1), (1200, 1), (1210, 1), (1220, 1), (1230, 1), (1240, 1), (1250, 1), (1260, 0), (1270, 1), (1280, 1), (1290, 1), (1300, 1), (1310, 1), (1320, 1), (1330, 0), (1340, 1), (1350, 0), (1360, 1), (1370, 0), (1380, 0), (1390, 0), (1400, 0), (1410, 0), (1420, 0), (1430, 0), (1440, 1), (1450, 1), (1460, 0), (1470, 0), (1480, 0), (1490, 0), (1500, 0), (1510, 0), (1520, 0), (1530, 0), (1540, 0), (1550, 0), (1560, 1), (1570, 1), (1580, 1), (1590, 0), (1600, 0), (1610, 0), (1620, 0), (1630, 0), (1640, 1), (1650, 1), (1660, 1), (1670, 1), (1680, 1), (1690, 1), (1700, 1), (1710, 1), (1720, 0), (1730, 0), (1740, 0), (1750, 0), (1760, 0), (1770, 0), (1780, 1), (1790, 0), (1800, 1), (1810, 0), (1820, 0), (1830, 0), (1840, 0), (1850, 0), (1860, 0), (1870, 0), (1880, 0), (1890, 0), (1900, 0), (1910, 1), (1920, 1), (1930, 0), (1940, 0), (1950, 0), (1960, 0), (1970, 0), (1980, 1), (1990, 1), (2000, 1), (2010, 1), (2020, 1), (2030, 1), (2040, 1), (2050, 1)]
Vdin0_13  din0_13  0 PWL (0n 0.0v 9.495n 0.0v 9.505n 1.8v 19.495n 1.8v 19.505n 1.8v 29.495n 1.8v 29.505n 1.8v 39.495n 1.8v 39.505n 1.8v 49.495n 1.8v 49.505n 1.8v 59.495n 1.8v 59.505n 0.0v 69.495n 0.0v 69.505n 0.0v 79.495n 0.0v 79.505n 0.0v 89.495n 0.0v 89.505n 0.0v 99.495n 0.0v 99.505n 0.0v 109.495n 0.0v 109.505n 0.0v 119.495n 0.0v 119.505n 1.8v 129.495n 1.8v 129.505n 1.8v 139.495n 1.8v 139.505n 1.8v 149.495n 1.8v 149.505n 1.8v 159.495n 1.8v 159.505n 1.8v 169.495n 1.8v 169.505n 1.8v 179.495n 1.8v 179.505n 1.8v 189.495n 1.8v 189.505n 1.8v 199.495n 1.8v 199.505n 0.0v 209.495n 0.0v 209.505n 0.0v 219.495n 0.0v 219.505n 0.0v 229.495n 0.0v 229.505n 0.0v 239.495n 0.0v 239.505n 0.0v 249.495n 0.0v 249.505n 0.0v 259.495n 0.0v 259.505n 0.0v 269.495n 0.0v 269.505n 0.0v 279.495n 0.0v 279.505n 0.0v 289.495n 0.0v 289.505n 0.0v 299.495n 0.0v 299.505n 0.0v 309.495n 0.0v 309.505n 0.0v 319.495n 0.0v 319.505n 0.0v 329.495n 0.0v 329.505n 0.0v 339.495n 0.0v 339.505n 0.0v 349.495n 0.0v 349.505n 0.0v 359.495n 0.0v 359.505n 1.8v 369.495n 1.8v 369.505n 1.8v 379.495n 1.8v 379.505n 1.8v 389.495n 1.8v 389.505n 1.8v 399.495n 1.8v 399.505n 1.8v 409.495n 1.8v 409.505n 0.0v 419.495n 0.0v 419.505n 0.0v 429.495n 0.0v 429.505n 0.0v 439.495n 0.0v 439.505n 0.0v 449.495n 0.0v 449.505n 0.0v 459.495n 0.0v 459.505n 0.0v 469.495n 0.0v 469.505n 0.0v 479.495n 0.0v 479.505n 0.0v 489.495n 0.0v 489.505n 0.0v 499.495n 0.0v 499.505n 0.0v 509.495n 0.0v 509.505n 1.8v 519.495n 1.8v 519.505n 1.8v 529.495n 1.8v 529.505n 0.0v 539.495n 0.0v 539.505n 1.8v 549.495n 1.8v 549.505n 1.8v 559.495n 1.8v 559.505n 1.8v 569.495n 1.8v 569.505n 1.8v 579.495n 1.8v 579.505n 0.0v 589.495n 0.0v 589.505n 0.0v 599.495n 0.0v 599.505n 0.0v 609.495n 0.0v 609.505n 0.0v 619.495n 0.0v 619.505n 0.0v 629.495n 0.0v 629.505n 1.8v 639.495n 1.8v 639.505n 1.8v 649.495n 1.8v 649.505n 1.8v 659.495n 1.8v 659.505n 1.8v 669.495n 1.8v 669.505n 1.8v 679.495n 1.8v 679.505n 1.8v 689.495n 1.8v 689.505n 1.8v 699.495n 1.8v 699.505n 0.0v 709.495n 0.0v 709.505n 0.0v 719.495n 0.0v 719.505n 0.0v 729.495n 0.0v 729.505n 0.0v 739.495n 0.0v 739.505n 1.8v 749.495n 1.8v 749.505n 1.8v 759.495n 1.8v 759.505n 0.0v 769.495n 0.0v 769.505n 1.8v 779.495n 1.8v 779.505n 0.0v 789.495n 0.0v 789.505n 0.0v 799.495n 0.0v 799.505n 0.0v 809.495n 0.0v 809.505n 0.0v 819.495n 0.0v 819.505n 0.0v 829.495n 0.0v 829.505n 0.0v 839.495n 0.0v 839.505n 1.8v 849.495n 1.8v 849.505n 1.8v 859.495n 1.8v 859.505n 1.8v 869.495n 1.8v 869.505n 0.0v 879.495n 0.0v 879.505n 0.0v 889.495n 0.0v 889.505n 0.0v 899.495n 0.0v 899.505n 0.0v 909.495n 0.0v 909.505n 0.0v 919.495n 0.0v 919.505n 0.0v 929.495n 0.0v 929.505n 0.0v 939.495n 0.0v 939.505n 0.0v 949.495n 0.0v 949.505n 0.0v 959.495n 0.0v 959.505n 0.0v 969.495n 0.0v 969.505n 0.0v 979.495n 0.0v 979.505n 1.8v 989.495n 1.8v 989.505n 1.8v 999.495n 1.8v 999.505n 0.0v 1009.495n 0.0v 1009.505n 0.0v 1019.495n 0.0v 1019.505n 1.8v 1029.495n 1.8v 1029.505n 1.8v 1039.495n 1.8v 1039.505n 1.8v 1049.495n 1.8v 1049.505n 1.8v 1059.495n 1.8v 1059.505n 1.8v 1069.495n 1.8v 1069.505n 1.8v 1079.495n 1.8v 1079.505n 1.8v 1089.495n 1.8v 1089.505n 1.8v 1099.495n 1.8v 1099.505n 1.8v 1109.495n 1.8v 1109.505n 1.8v 1119.495n 1.8v 1119.505n 0.0v 1129.495n 0.0v 1129.505n 0.0v 1139.495n 0.0v 1139.505n 1.8v 1149.495n 1.8v 1149.505n 1.8v 1159.495n 1.8v 1159.505n 1.8v 1169.495n 1.8v 1169.505n 1.8v 1179.495n 1.8v 1179.505n 1.8v 1189.495n 1.8v 1189.505n 1.8v 1199.495n 1.8v 1199.505n 1.8v 1209.495n 1.8v 1209.505n 1.8v 1219.495n 1.8v 1219.505n 1.8v 1229.495n 1.8v 1229.505n 1.8v 1239.495n 1.8v 1239.505n 1.8v 1249.495n 1.8v 1249.505n 1.8v 1259.495n 1.8v 1259.505n 0.0v 1269.495n 0.0v 1269.505n 1.8v 1279.495n 1.8v 1279.505n 1.8v 1289.495n 1.8v 1289.505n 1.8v 1299.495n 1.8v 1299.505n 1.8v 1309.495n 1.8v 1309.505n 1.8v 1319.495n 1.8v 1319.505n 1.8v 1329.495n 1.8v 1329.505n 0.0v 1339.495n 0.0v 1339.505n 1.8v 1349.495n 1.8v 1349.505n 0.0v 1359.495n 0.0v 1359.505n 1.8v 1369.495n 1.8v 1369.505n 0.0v 1379.495n 0.0v 1379.505n 0.0v 1389.495n 0.0v 1389.505n 0.0v 1399.495n 0.0v 1399.505n 0.0v 1409.495n 0.0v 1409.505n 0.0v 1419.495n 0.0v 1419.505n 0.0v 1429.495n 0.0v 1429.505n 0.0v 1439.495n 0.0v 1439.505n 1.8v 1449.495n 1.8v 1449.505n 1.8v 1459.495n 1.8v 1459.505n 0.0v 1469.495n 0.0v 1469.505n 0.0v 1479.495n 0.0v 1479.505n 0.0v 1489.495n 0.0v 1489.505n 0.0v 1499.495n 0.0v 1499.505n 0.0v 1509.495n 0.0v 1509.505n 0.0v 1519.495n 0.0v 1519.505n 0.0v 1529.495n 0.0v 1529.505n 0.0v 1539.495n 0.0v 1539.505n 0.0v 1549.495n 0.0v 1549.505n 0.0v 1559.495n 0.0v 1559.505n 1.8v 1569.495n 1.8v 1569.505n 1.8v 1579.495n 1.8v 1579.505n 1.8v 1589.495n 1.8v 1589.505n 0.0v 1599.495n 0.0v 1599.505n 0.0v 1609.495n 0.0v 1609.505n 0.0v 1619.495n 0.0v 1619.505n 0.0v 1629.495n 0.0v 1629.505n 0.0v 1639.495n 0.0v 1639.505n 1.8v 1649.495n 1.8v 1649.505n 1.8v 1659.495n 1.8v 1659.505n 1.8v 1669.495n 1.8v 1669.505n 1.8v 1679.495n 1.8v 1679.505n 1.8v 1689.495n 1.8v 1689.505n 1.8v 1699.495n 1.8v 1699.505n 1.8v 1709.495n 1.8v 1709.505n 1.8v 1719.495n 1.8v 1719.505n 0.0v 1729.495n 0.0v 1729.505n 0.0v 1739.495n 0.0v 1739.505n 0.0v 1749.495n 0.0v 1749.505n 0.0v 1759.495n 0.0v 1759.505n 0.0v 1769.495n 0.0v 1769.505n 0.0v 1779.495n 0.0v 1779.505n 1.8v 1789.495n 1.8v 1789.505n 0.0v 1799.495n 0.0v 1799.505n 1.8v 1809.495n 1.8v 1809.505n 0.0v 1819.495n 0.0v 1819.505n 0.0v 1829.495n 0.0v 1829.505n 0.0v 1839.495n 0.0v 1839.505n 0.0v 1849.495n 0.0v 1849.505n 0.0v 1859.495n 0.0v 1859.505n 0.0v 1869.495n 0.0v 1869.505n 0.0v 1879.495n 0.0v 1879.505n 0.0v 1889.495n 0.0v 1889.505n 0.0v 1899.495n 0.0v 1899.505n 0.0v 1909.495n 0.0v 1909.505n 1.8v 1919.495n 1.8v 1919.505n 1.8v 1929.495n 1.8v 1929.505n 0.0v 1939.495n 0.0v 1939.505n 0.0v 1949.495n 0.0v 1949.505n 0.0v 1959.495n 0.0v 1959.505n 0.0v 1969.495n 0.0v 1969.505n 0.0v 1979.495n 0.0v 1979.505n 1.8v 1989.495n 1.8v 1989.505n 1.8v 1999.495n 1.8v 1999.505n 1.8v 2009.495n 1.8v 2009.505n 1.8v 2019.495n 1.8v 2019.505n 1.8v 2029.495n 1.8v 2029.505n 1.8v 2039.495n 1.8v 2039.505n 1.8v 2049.495n 1.8v 2049.505n 1.8v )
* (time, data): [(0, 0), (10, 1), (20, 0), (30, 0), (40, 0), (50, 0), (60, 1), (70, 1), (80, 1), (90, 1), (100, 1), (110, 1), (120, 0), (130, 0), (140, 0), (150, 0), (160, 0), (170, 0), (180, 0), (190, 0), (200, 0), (210, 0), (220, 1), (230, 1), (240, 1), (250, 1), (260, 1), (270, 1), (280, 1), (290, 1), (300, 1), (310, 1), (320, 0), (330, 0), (340, 0), (350, 0), (360, 1), (370, 1), (380, 0), (390, 0), (400, 0), (410, 1), (420, 1), (430, 1), (440, 1), (450, 1), (460, 1), (470, 1), (480, 1), (490, 0), (500, 0), (510, 0), (520, 0), (530, 0), (540, 0), (550, 0), (560, 0), (570, 0), (580, 1), (590, 1), (600, 1), (610, 1), (620, 1), (630, 0), (640, 0), (650, 0), (660, 0), (670, 0), (680, 0), (690, 0), (700, 1), (710, 1), (720, 1), (730, 0), (740, 0), (750, 0), (760, 0), (770, 0), (780, 0), (790, 0), (800, 1), (810, 1), (820, 1), (830, 1), (840, 0), (850, 0), (860, 0), (870, 1), (880, 1), (890, 1), (900, 1), (910, 1), (920, 0), (930, 0), (940, 0), (950, 0), (960, 0), (970, 1), (980, 1), (990, 1), (1000, 0), (1010, 0), (1020, 0), (1030, 0), (1040, 0), (1050, 0), (1060, 0), (1070, 0), (1080, 0), (1090, 0), (1100, 0), (1110, 0), (1120, 0), (1130, 0), (1140, 0), (1150, 0), (1160, 1), (1170, 0), (1180, 0), (1190, 0), (1200, 1), (1210, 1), (1220, 1), (1230, 0), (1240, 1), (1250, 0), (1260, 1), (1270, 1), (1280, 1), (1290, 1), (1300, 1), (1310, 1), (1320, 1), (1330, 1), (1340, 1), (1350, 0), (1360, 1), (1370, 0), (1380, 0), (1390, 0), (1400, 0), (1410, 0), (1420, 0), (1430, 0), (1440, 1), (1450, 1), (1460, 0), (1470, 1), (1480, 1), (1490, 1), (1500, 1), (1510, 1), (1520, 1), (1530, 1), (1540, 1), (1550, 0), (1560, 0), (1570, 0), (1580, 0), (1590, 1), (1600, 1), (1610, 1), (1620, 1), (1630, 1), (1640, 0), (1650, 0), (1660, 0), (1670, 0), (1680, 0), (1690, 0), (1700, 0), (1710, 0), (1720, 0), (1730, 0), (1740, 0), (1750, 0), (1760, 0), (1770, 0), (1780, 1), (1790, 1), (1800, 1), (1810, 1), (1820, 1), (1830, 1), (1840, 1), (1850, 1), (1860, 1), (1870, 1), (1880, 0), (1890, 0), (1900, 1), (1910, 0), (1920, 0), (1930, 0), (1940, 0), (1950, 0), (1960, 0), (1970, 0), (1980, 0), (1990, 0), (2000, 0), (2010, 0), (2020, 0), (2030, 0), (2040, 0), (2050, 0)]
Vdin0_14  din0_14  0 PWL (0n 0.0v 9.495n 0.0v 9.505n 1.8v 19.495n 1.8v 19.505n 0.0v 29.495n 0.0v 29.505n 0.0v 39.495n 0.0v 39.505n 0.0v 49.495n 0.0v 49.505n 0.0v 59.495n 0.0v 59.505n 1.8v 69.495n 1.8v 69.505n 1.8v 79.495n 1.8v 79.505n 1.8v 89.495n 1.8v 89.505n 1.8v 99.495n 1.8v 99.505n 1.8v 109.495n 1.8v 109.505n 1.8v 119.495n 1.8v 119.505n 0.0v 129.495n 0.0v 129.505n 0.0v 139.495n 0.0v 139.505n 0.0v 149.495n 0.0v 149.505n 0.0v 159.495n 0.0v 159.505n 0.0v 169.495n 0.0v 169.505n 0.0v 179.495n 0.0v 179.505n 0.0v 189.495n 0.0v 189.505n 0.0v 199.495n 0.0v 199.505n 0.0v 209.495n 0.0v 209.505n 0.0v 219.495n 0.0v 219.505n 1.8v 229.495n 1.8v 229.505n 1.8v 239.495n 1.8v 239.505n 1.8v 249.495n 1.8v 249.505n 1.8v 259.495n 1.8v 259.505n 1.8v 269.495n 1.8v 269.505n 1.8v 279.495n 1.8v 279.505n 1.8v 289.495n 1.8v 289.505n 1.8v 299.495n 1.8v 299.505n 1.8v 309.495n 1.8v 309.505n 1.8v 319.495n 1.8v 319.505n 0.0v 329.495n 0.0v 329.505n 0.0v 339.495n 0.0v 339.505n 0.0v 349.495n 0.0v 349.505n 0.0v 359.495n 0.0v 359.505n 1.8v 369.495n 1.8v 369.505n 1.8v 379.495n 1.8v 379.505n 0.0v 389.495n 0.0v 389.505n 0.0v 399.495n 0.0v 399.505n 0.0v 409.495n 0.0v 409.505n 1.8v 419.495n 1.8v 419.505n 1.8v 429.495n 1.8v 429.505n 1.8v 439.495n 1.8v 439.505n 1.8v 449.495n 1.8v 449.505n 1.8v 459.495n 1.8v 459.505n 1.8v 469.495n 1.8v 469.505n 1.8v 479.495n 1.8v 479.505n 1.8v 489.495n 1.8v 489.505n 0.0v 499.495n 0.0v 499.505n 0.0v 509.495n 0.0v 509.505n 0.0v 519.495n 0.0v 519.505n 0.0v 529.495n 0.0v 529.505n 0.0v 539.495n 0.0v 539.505n 0.0v 549.495n 0.0v 549.505n 0.0v 559.495n 0.0v 559.505n 0.0v 569.495n 0.0v 569.505n 0.0v 579.495n 0.0v 579.505n 1.8v 589.495n 1.8v 589.505n 1.8v 599.495n 1.8v 599.505n 1.8v 609.495n 1.8v 609.505n 1.8v 619.495n 1.8v 619.505n 1.8v 629.495n 1.8v 629.505n 0.0v 639.495n 0.0v 639.505n 0.0v 649.495n 0.0v 649.505n 0.0v 659.495n 0.0v 659.505n 0.0v 669.495n 0.0v 669.505n 0.0v 679.495n 0.0v 679.505n 0.0v 689.495n 0.0v 689.505n 0.0v 699.495n 0.0v 699.505n 1.8v 709.495n 1.8v 709.505n 1.8v 719.495n 1.8v 719.505n 1.8v 729.495n 1.8v 729.505n 0.0v 739.495n 0.0v 739.505n 0.0v 749.495n 0.0v 749.505n 0.0v 759.495n 0.0v 759.505n 0.0v 769.495n 0.0v 769.505n 0.0v 779.495n 0.0v 779.505n 0.0v 789.495n 0.0v 789.505n 0.0v 799.495n 0.0v 799.505n 1.8v 809.495n 1.8v 809.505n 1.8v 819.495n 1.8v 819.505n 1.8v 829.495n 1.8v 829.505n 1.8v 839.495n 1.8v 839.505n 0.0v 849.495n 0.0v 849.505n 0.0v 859.495n 0.0v 859.505n 0.0v 869.495n 0.0v 869.505n 1.8v 879.495n 1.8v 879.505n 1.8v 889.495n 1.8v 889.505n 1.8v 899.495n 1.8v 899.505n 1.8v 909.495n 1.8v 909.505n 1.8v 919.495n 1.8v 919.505n 0.0v 929.495n 0.0v 929.505n 0.0v 939.495n 0.0v 939.505n 0.0v 949.495n 0.0v 949.505n 0.0v 959.495n 0.0v 959.505n 0.0v 969.495n 0.0v 969.505n 1.8v 979.495n 1.8v 979.505n 1.8v 989.495n 1.8v 989.505n 1.8v 999.495n 1.8v 999.505n 0.0v 1009.495n 0.0v 1009.505n 0.0v 1019.495n 0.0v 1019.505n 0.0v 1029.495n 0.0v 1029.505n 0.0v 1039.495n 0.0v 1039.505n 0.0v 1049.495n 0.0v 1049.505n 0.0v 1059.495n 0.0v 1059.505n 0.0v 1069.495n 0.0v 1069.505n 0.0v 1079.495n 0.0v 1079.505n 0.0v 1089.495n 0.0v 1089.505n 0.0v 1099.495n 0.0v 1099.505n 0.0v 1109.495n 0.0v 1109.505n 0.0v 1119.495n 0.0v 1119.505n 0.0v 1129.495n 0.0v 1129.505n 0.0v 1139.495n 0.0v 1139.505n 0.0v 1149.495n 0.0v 1149.505n 0.0v 1159.495n 0.0v 1159.505n 1.8v 1169.495n 1.8v 1169.505n 0.0v 1179.495n 0.0v 1179.505n 0.0v 1189.495n 0.0v 1189.505n 0.0v 1199.495n 0.0v 1199.505n 1.8v 1209.495n 1.8v 1209.505n 1.8v 1219.495n 1.8v 1219.505n 1.8v 1229.495n 1.8v 1229.505n 0.0v 1239.495n 0.0v 1239.505n 1.8v 1249.495n 1.8v 1249.505n 0.0v 1259.495n 0.0v 1259.505n 1.8v 1269.495n 1.8v 1269.505n 1.8v 1279.495n 1.8v 1279.505n 1.8v 1289.495n 1.8v 1289.505n 1.8v 1299.495n 1.8v 1299.505n 1.8v 1309.495n 1.8v 1309.505n 1.8v 1319.495n 1.8v 1319.505n 1.8v 1329.495n 1.8v 1329.505n 1.8v 1339.495n 1.8v 1339.505n 1.8v 1349.495n 1.8v 1349.505n 0.0v 1359.495n 0.0v 1359.505n 1.8v 1369.495n 1.8v 1369.505n 0.0v 1379.495n 0.0v 1379.505n 0.0v 1389.495n 0.0v 1389.505n 0.0v 1399.495n 0.0v 1399.505n 0.0v 1409.495n 0.0v 1409.505n 0.0v 1419.495n 0.0v 1419.505n 0.0v 1429.495n 0.0v 1429.505n 0.0v 1439.495n 0.0v 1439.505n 1.8v 1449.495n 1.8v 1449.505n 1.8v 1459.495n 1.8v 1459.505n 0.0v 1469.495n 0.0v 1469.505n 1.8v 1479.495n 1.8v 1479.505n 1.8v 1489.495n 1.8v 1489.505n 1.8v 1499.495n 1.8v 1499.505n 1.8v 1509.495n 1.8v 1509.505n 1.8v 1519.495n 1.8v 1519.505n 1.8v 1529.495n 1.8v 1529.505n 1.8v 1539.495n 1.8v 1539.505n 1.8v 1549.495n 1.8v 1549.505n 0.0v 1559.495n 0.0v 1559.505n 0.0v 1569.495n 0.0v 1569.505n 0.0v 1579.495n 0.0v 1579.505n 0.0v 1589.495n 0.0v 1589.505n 1.8v 1599.495n 1.8v 1599.505n 1.8v 1609.495n 1.8v 1609.505n 1.8v 1619.495n 1.8v 1619.505n 1.8v 1629.495n 1.8v 1629.505n 1.8v 1639.495n 1.8v 1639.505n 0.0v 1649.495n 0.0v 1649.505n 0.0v 1659.495n 0.0v 1659.505n 0.0v 1669.495n 0.0v 1669.505n 0.0v 1679.495n 0.0v 1679.505n 0.0v 1689.495n 0.0v 1689.505n 0.0v 1699.495n 0.0v 1699.505n 0.0v 1709.495n 0.0v 1709.505n 0.0v 1719.495n 0.0v 1719.505n 0.0v 1729.495n 0.0v 1729.505n 0.0v 1739.495n 0.0v 1739.505n 0.0v 1749.495n 0.0v 1749.505n 0.0v 1759.495n 0.0v 1759.505n 0.0v 1769.495n 0.0v 1769.505n 0.0v 1779.495n 0.0v 1779.505n 1.8v 1789.495n 1.8v 1789.505n 1.8v 1799.495n 1.8v 1799.505n 1.8v 1809.495n 1.8v 1809.505n 1.8v 1819.495n 1.8v 1819.505n 1.8v 1829.495n 1.8v 1829.505n 1.8v 1839.495n 1.8v 1839.505n 1.8v 1849.495n 1.8v 1849.505n 1.8v 1859.495n 1.8v 1859.505n 1.8v 1869.495n 1.8v 1869.505n 1.8v 1879.495n 1.8v 1879.505n 0.0v 1889.495n 0.0v 1889.505n 0.0v 1899.495n 0.0v 1899.505n 1.8v 1909.495n 1.8v 1909.505n 0.0v 1919.495n 0.0v 1919.505n 0.0v 1929.495n 0.0v 1929.505n 0.0v 1939.495n 0.0v 1939.505n 0.0v 1949.495n 0.0v 1949.505n 0.0v 1959.495n 0.0v 1959.505n 0.0v 1969.495n 0.0v 1969.505n 0.0v 1979.495n 0.0v 1979.505n 0.0v 1989.495n 0.0v 1989.505n 0.0v 1999.495n 0.0v 1999.505n 0.0v 2009.495n 0.0v 2009.505n 0.0v 2019.495n 0.0v 2019.505n 0.0v 2029.495n 0.0v 2029.505n 0.0v 2039.495n 0.0v 2039.505n 0.0v 2049.495n 0.0v 2049.505n 0.0v )
* (time, data): [(0, 0), (10, 0), (20, 1), (30, 1), (40, 1), (50, 1), (60, 0), (70, 0), (80, 0), (90, 1), (100, 1), (110, 1), (120, 0), (130, 0), (140, 0), (150, 0), (160, 0), (170, 0), (180, 0), (190, 0), (200, 1), (210, 1), (220, 0), (230, 0), (240, 0), (250, 1), (260, 1), (270, 1), (280, 1), (290, 1), (300, 1), (310, 1), (320, 1), (330, 1), (340, 1), (350, 1), (360, 1), (370, 1), (380, 1), (390, 1), (400, 1), (410, 0), (420, 0), (430, 0), (440, 0), (450, 0), (460, 0), (470, 0), (480, 0), (490, 1), (500, 1), (510, 1), (520, 1), (530, 0), (540, 1), (550, 1), (560, 1), (570, 1), (580, 0), (590, 1), (600, 1), (610, 1), (620, 1), (630, 1), (640, 1), (650, 1), (660, 1), (670, 0), (680, 0), (690, 0), (700, 1), (710, 1), (720, 1), (730, 0), (740, 1), (750, 1), (760, 1), (770, 1), (780, 1), (790, 1), (800, 1), (810, 1), (820, 1), (830, 1), (840, 1), (850, 1), (860, 1), (870, 0), (880, 0), (890, 0), (900, 0), (910, 0), (920, 0), (930, 0), (940, 0), (950, 0), (960, 0), (970, 1), (980, 0), (990, 0), (1000, 1), (1010, 1), (1020, 1), (1030, 1), (1040, 1), (1050, 1), (1060, 1), (1070, 1), (1080, 1), (1090, 1), (1100, 1), (1110, 1), (1120, 0), (1130, 0), (1140, 1), (1150, 1), (1160, 0), (1170, 0), (1180, 0), (1190, 0), (1200, 1), (1210, 1), (1220, 1), (1230, 0), (1240, 0), (1250, 0), (1260, 0), (1270, 1), (1280, 1), (1290, 1), (1300, 1), (1310, 1), (1320, 1), (1330, 1), (1340, 1), (1350, 0), (1360, 1), (1370, 1), (1380, 1), (1390, 1), (1400, 1), (1410, 1), (1420, 1), (1430, 1), (1440, 1), (1450, 1), (1460, 0), (1470, 0), (1480, 0), (1490, 0), (1500, 0), (1510, 0), (1520, 0), (1530, 0), (1540, 0), (1550, 1), (1560, 1), (1570, 1), (1580, 1), (1590, 1), (1600, 1), (1610, 1), (1620, 1), (1630, 1), (1640, 0), (1650, 0), (1660, 0), (1670, 0), (1680, 0), (1690, 0), (1700, 0), (1710, 0), (1720, 1), (1730, 1), (1740, 1), (1750, 1), (1760, 1), (1770, 0), (1780, 1), (1790, 0), (1800, 1), (1810, 0), (1820, 0), (1830, 0), (1840, 0), (1850, 0), (1860, 0), (1870, 0), (1880, 1), (1890, 1), (1900, 1), (1910, 1), (1920, 1), (1930, 1), (1940, 1), (1950, 1), (1960, 1), (1970, 1), (1980, 0), (1990, 0), (2000, 0), (2010, 0), (2020, 0), (2030, 0), (2040, 0), (2050, 0)]
Vdin0_15  din0_15  0 PWL (0n 0.0v 9.495n 0.0v 9.505n 0.0v 19.495n 0.0v 19.505n 1.8v 29.495n 1.8v 29.505n 1.8v 39.495n 1.8v 39.505n 1.8v 49.495n 1.8v 49.505n 1.8v 59.495n 1.8v 59.505n 0.0v 69.495n 0.0v 69.505n 0.0v 79.495n 0.0v 79.505n 0.0v 89.495n 0.0v 89.505n 1.8v 99.495n 1.8v 99.505n 1.8v 109.495n 1.8v 109.505n 1.8v 119.495n 1.8v 119.505n 0.0v 129.495n 0.0v 129.505n 0.0v 139.495n 0.0v 139.505n 0.0v 149.495n 0.0v 149.505n 0.0v 159.495n 0.0v 159.505n 0.0v 169.495n 0.0v 169.505n 0.0v 179.495n 0.0v 179.505n 0.0v 189.495n 0.0v 189.505n 0.0v 199.495n 0.0v 199.505n 1.8v 209.495n 1.8v 209.505n 1.8v 219.495n 1.8v 219.505n 0.0v 229.495n 0.0v 229.505n 0.0v 239.495n 0.0v 239.505n 0.0v 249.495n 0.0v 249.505n 1.8v 259.495n 1.8v 259.505n 1.8v 269.495n 1.8v 269.505n 1.8v 279.495n 1.8v 279.505n 1.8v 289.495n 1.8v 289.505n 1.8v 299.495n 1.8v 299.505n 1.8v 309.495n 1.8v 309.505n 1.8v 319.495n 1.8v 319.505n 1.8v 329.495n 1.8v 329.505n 1.8v 339.495n 1.8v 339.505n 1.8v 349.495n 1.8v 349.505n 1.8v 359.495n 1.8v 359.505n 1.8v 369.495n 1.8v 369.505n 1.8v 379.495n 1.8v 379.505n 1.8v 389.495n 1.8v 389.505n 1.8v 399.495n 1.8v 399.505n 1.8v 409.495n 1.8v 409.505n 0.0v 419.495n 0.0v 419.505n 0.0v 429.495n 0.0v 429.505n 0.0v 439.495n 0.0v 439.505n 0.0v 449.495n 0.0v 449.505n 0.0v 459.495n 0.0v 459.505n 0.0v 469.495n 0.0v 469.505n 0.0v 479.495n 0.0v 479.505n 0.0v 489.495n 0.0v 489.505n 1.8v 499.495n 1.8v 499.505n 1.8v 509.495n 1.8v 509.505n 1.8v 519.495n 1.8v 519.505n 1.8v 529.495n 1.8v 529.505n 0.0v 539.495n 0.0v 539.505n 1.8v 549.495n 1.8v 549.505n 1.8v 559.495n 1.8v 559.505n 1.8v 569.495n 1.8v 569.505n 1.8v 579.495n 1.8v 579.505n 0.0v 589.495n 0.0v 589.505n 1.8v 599.495n 1.8v 599.505n 1.8v 609.495n 1.8v 609.505n 1.8v 619.495n 1.8v 619.505n 1.8v 629.495n 1.8v 629.505n 1.8v 639.495n 1.8v 639.505n 1.8v 649.495n 1.8v 649.505n 1.8v 659.495n 1.8v 659.505n 1.8v 669.495n 1.8v 669.505n 0.0v 679.495n 0.0v 679.505n 0.0v 689.495n 0.0v 689.505n 0.0v 699.495n 0.0v 699.505n 1.8v 709.495n 1.8v 709.505n 1.8v 719.495n 1.8v 719.505n 1.8v 729.495n 1.8v 729.505n 0.0v 739.495n 0.0v 739.505n 1.8v 749.495n 1.8v 749.505n 1.8v 759.495n 1.8v 759.505n 1.8v 769.495n 1.8v 769.505n 1.8v 779.495n 1.8v 779.505n 1.8v 789.495n 1.8v 789.505n 1.8v 799.495n 1.8v 799.505n 1.8v 809.495n 1.8v 809.505n 1.8v 819.495n 1.8v 819.505n 1.8v 829.495n 1.8v 829.505n 1.8v 839.495n 1.8v 839.505n 1.8v 849.495n 1.8v 849.505n 1.8v 859.495n 1.8v 859.505n 1.8v 869.495n 1.8v 869.505n 0.0v 879.495n 0.0v 879.505n 0.0v 889.495n 0.0v 889.505n 0.0v 899.495n 0.0v 899.505n 0.0v 909.495n 0.0v 909.505n 0.0v 919.495n 0.0v 919.505n 0.0v 929.495n 0.0v 929.505n 0.0v 939.495n 0.0v 939.505n 0.0v 949.495n 0.0v 949.505n 0.0v 959.495n 0.0v 959.505n 0.0v 969.495n 0.0v 969.505n 1.8v 979.495n 1.8v 979.505n 0.0v 989.495n 0.0v 989.505n 0.0v 999.495n 0.0v 999.505n 1.8v 1009.495n 1.8v 1009.505n 1.8v 1019.495n 1.8v 1019.505n 1.8v 1029.495n 1.8v 1029.505n 1.8v 1039.495n 1.8v 1039.505n 1.8v 1049.495n 1.8v 1049.505n 1.8v 1059.495n 1.8v 1059.505n 1.8v 1069.495n 1.8v 1069.505n 1.8v 1079.495n 1.8v 1079.505n 1.8v 1089.495n 1.8v 1089.505n 1.8v 1099.495n 1.8v 1099.505n 1.8v 1109.495n 1.8v 1109.505n 1.8v 1119.495n 1.8v 1119.505n 0.0v 1129.495n 0.0v 1129.505n 0.0v 1139.495n 0.0v 1139.505n 1.8v 1149.495n 1.8v 1149.505n 1.8v 1159.495n 1.8v 1159.505n 0.0v 1169.495n 0.0v 1169.505n 0.0v 1179.495n 0.0v 1179.505n 0.0v 1189.495n 0.0v 1189.505n 0.0v 1199.495n 0.0v 1199.505n 1.8v 1209.495n 1.8v 1209.505n 1.8v 1219.495n 1.8v 1219.505n 1.8v 1229.495n 1.8v 1229.505n 0.0v 1239.495n 0.0v 1239.505n 0.0v 1249.495n 0.0v 1249.505n 0.0v 1259.495n 0.0v 1259.505n 0.0v 1269.495n 0.0v 1269.505n 1.8v 1279.495n 1.8v 1279.505n 1.8v 1289.495n 1.8v 1289.505n 1.8v 1299.495n 1.8v 1299.505n 1.8v 1309.495n 1.8v 1309.505n 1.8v 1319.495n 1.8v 1319.505n 1.8v 1329.495n 1.8v 1329.505n 1.8v 1339.495n 1.8v 1339.505n 1.8v 1349.495n 1.8v 1349.505n 0.0v 1359.495n 0.0v 1359.505n 1.8v 1369.495n 1.8v 1369.505n 1.8v 1379.495n 1.8v 1379.505n 1.8v 1389.495n 1.8v 1389.505n 1.8v 1399.495n 1.8v 1399.505n 1.8v 1409.495n 1.8v 1409.505n 1.8v 1419.495n 1.8v 1419.505n 1.8v 1429.495n 1.8v 1429.505n 1.8v 1439.495n 1.8v 1439.505n 1.8v 1449.495n 1.8v 1449.505n 1.8v 1459.495n 1.8v 1459.505n 0.0v 1469.495n 0.0v 1469.505n 0.0v 1479.495n 0.0v 1479.505n 0.0v 1489.495n 0.0v 1489.505n 0.0v 1499.495n 0.0v 1499.505n 0.0v 1509.495n 0.0v 1509.505n 0.0v 1519.495n 0.0v 1519.505n 0.0v 1529.495n 0.0v 1529.505n 0.0v 1539.495n 0.0v 1539.505n 0.0v 1549.495n 0.0v 1549.505n 1.8v 1559.495n 1.8v 1559.505n 1.8v 1569.495n 1.8v 1569.505n 1.8v 1579.495n 1.8v 1579.505n 1.8v 1589.495n 1.8v 1589.505n 1.8v 1599.495n 1.8v 1599.505n 1.8v 1609.495n 1.8v 1609.505n 1.8v 1619.495n 1.8v 1619.505n 1.8v 1629.495n 1.8v 1629.505n 1.8v 1639.495n 1.8v 1639.505n 0.0v 1649.495n 0.0v 1649.505n 0.0v 1659.495n 0.0v 1659.505n 0.0v 1669.495n 0.0v 1669.505n 0.0v 1679.495n 0.0v 1679.505n 0.0v 1689.495n 0.0v 1689.505n 0.0v 1699.495n 0.0v 1699.505n 0.0v 1709.495n 0.0v 1709.505n 0.0v 1719.495n 0.0v 1719.505n 1.8v 1729.495n 1.8v 1729.505n 1.8v 1739.495n 1.8v 1739.505n 1.8v 1749.495n 1.8v 1749.505n 1.8v 1759.495n 1.8v 1759.505n 1.8v 1769.495n 1.8v 1769.505n 0.0v 1779.495n 0.0v 1779.505n 1.8v 1789.495n 1.8v 1789.505n 0.0v 1799.495n 0.0v 1799.505n 1.8v 1809.495n 1.8v 1809.505n 0.0v 1819.495n 0.0v 1819.505n 0.0v 1829.495n 0.0v 1829.505n 0.0v 1839.495n 0.0v 1839.505n 0.0v 1849.495n 0.0v 1849.505n 0.0v 1859.495n 0.0v 1859.505n 0.0v 1869.495n 0.0v 1869.505n 0.0v 1879.495n 0.0v 1879.505n 1.8v 1889.495n 1.8v 1889.505n 1.8v 1899.495n 1.8v 1899.505n 1.8v 1909.495n 1.8v 1909.505n 1.8v 1919.495n 1.8v 1919.505n 1.8v 1929.495n 1.8v 1929.505n 1.8v 1939.495n 1.8v 1939.505n 1.8v 1949.495n 1.8v 1949.505n 1.8v 1959.495n 1.8v 1959.505n 1.8v 1969.495n 1.8v 1969.505n 1.8v 1979.495n 1.8v 1979.505n 0.0v 1989.495n 0.0v 1989.505n 0.0v 1999.495n 0.0v 1999.505n 0.0v 2009.495n 0.0v 2009.505n 0.0v 2019.495n 0.0v 2019.505n 0.0v 2029.495n 0.0v 2029.505n 0.0v 2039.495n 0.0v 2039.505n 0.0v 2049.495n 0.0v 2049.505n 0.0v )
* (time, data): [(0, 0), (10, 1), (20, 1), (30, 0), (40, 0), (50, 0), (60, 1), (70, 1), (80, 1), (90, 1), (100, 1), (110, 1), (120, 0), (130, 0), (140, 0), (150, 0), (160, 0), (170, 0), (180, 0), (190, 0), (200, 0), (210, 0), (220, 0), (230, 0), (240, 0), (250, 0), (260, 0), (270, 0), (280, 0), (290, 0), (300, 0), (310, 0), (320, 0), (330, 0), (340, 0), (350, 0), (360, 1), (370, 1), (380, 1), (390, 1), (400, 1), (410, 1), (420, 0), (430, 0), (440, 0), (450, 0), (460, 0), (470, 0), (480, 0), (490, 0), (500, 0), (510, 0), (520, 0), (530, 0), (540, 1), (550, 1), (560, 1), (570, 1), (580, 0), (590, 0), (600, 0), (610, 0), (620, 0), (630, 0), (640, 0), (650, 0), (660, 1), (670, 0), (680, 0), (690, 0), (700, 1), (710, 1), (720, 1), (730, 0), (740, 0), (750, 0), (760, 1), (770, 1), (780, 0), (790, 0), (800, 1), (810, 1), (820, 1), (830, 1), (840, 1), (850, 1), (860, 1), (870, 1), (880, 1), (890, 1), (900, 1), (910, 1), (920, 0), (930, 0), (940, 0), (950, 0), (960, 0), (970, 0), (980, 0), (990, 0), (1000, 1), (1010, 1), (1020, 1), (1030, 1), (1040, 1), (1050, 1), (1060, 1), (1070, 1), (1080, 1), (1090, 1), (1100, 1), (1110, 1), (1120, 1), (1130, 1), (1140, 0), (1150, 0), (1160, 0), (1170, 0), (1180, 0), (1190, 0), (1200, 0), (1210, 0), (1220, 0), (1230, 1), (1240, 0), (1250, 0), (1260, 0), (1270, 1), (1280, 1), (1290, 1), (1300, 1), (1310, 1), (1320, 1), (1330, 1), (1340, 1), (1350, 0), (1360, 0), (1370, 1), (1380, 1), (1390, 1), (1400, 1), (1410, 1), (1420, 1), (1430, 1), (1440, 0), (1450, 0), (1460, 0), (1470, 1), (1480, 1), (1490, 1), (1500, 1), (1510, 1), (1520, 1), (1530, 1), (1540, 1), (1550, 0), (1560, 1), (1570, 1), (1580, 1), (1590, 1), (1600, 1), (1610, 1), (1620, 1), (1630, 1), (1640, 1), (1650, 1), (1660, 1), (1670, 1), (1680, 1), (1690, 1), (1700, 1), (1710, 1), (1720, 0), (1730, 0), (1740, 0), (1750, 0), (1760, 0), (1770, 0), (1780, 0), (1790, 1), (1800, 0), (1810, 1), (1820, 1), (1830, 1), (1840, 1), (1850, 1), (1860, 1), (1870, 1), (1880, 1), (1890, 1), (1900, 1), (1910, 1), (1920, 1), (1930, 1), (1940, 1), (1950, 1), (1960, 1), (1970, 1), (1980, 0), (1990, 0), (2000, 0), (2010, 0), (2020, 0), (2030, 0), (2040, 0), (2050, 0)]
Vdin0_16  din0_16  0 PWL (0n 0.0v 9.495n 0.0v 9.505n 1.8v 19.495n 1.8v 19.505n 1.8v 29.495n 1.8v 29.505n 0.0v 39.495n 0.0v 39.505n 0.0v 49.495n 0.0v 49.505n 0.0v 59.495n 0.0v 59.505n 1.8v 69.495n 1.8v 69.505n 1.8v 79.495n 1.8v 79.505n 1.8v 89.495n 1.8v 89.505n 1.8v 99.495n 1.8v 99.505n 1.8v 109.495n 1.8v 109.505n 1.8v 119.495n 1.8v 119.505n 0.0v 129.495n 0.0v 129.505n 0.0v 139.495n 0.0v 139.505n 0.0v 149.495n 0.0v 149.505n 0.0v 159.495n 0.0v 159.505n 0.0v 169.495n 0.0v 169.505n 0.0v 179.495n 0.0v 179.505n 0.0v 189.495n 0.0v 189.505n 0.0v 199.495n 0.0v 199.505n 0.0v 209.495n 0.0v 209.505n 0.0v 219.495n 0.0v 219.505n 0.0v 229.495n 0.0v 229.505n 0.0v 239.495n 0.0v 239.505n 0.0v 249.495n 0.0v 249.505n 0.0v 259.495n 0.0v 259.505n 0.0v 269.495n 0.0v 269.505n 0.0v 279.495n 0.0v 279.505n 0.0v 289.495n 0.0v 289.505n 0.0v 299.495n 0.0v 299.505n 0.0v 309.495n 0.0v 309.505n 0.0v 319.495n 0.0v 319.505n 0.0v 329.495n 0.0v 329.505n 0.0v 339.495n 0.0v 339.505n 0.0v 349.495n 0.0v 349.505n 0.0v 359.495n 0.0v 359.505n 1.8v 369.495n 1.8v 369.505n 1.8v 379.495n 1.8v 379.505n 1.8v 389.495n 1.8v 389.505n 1.8v 399.495n 1.8v 399.505n 1.8v 409.495n 1.8v 409.505n 1.8v 419.495n 1.8v 419.505n 0.0v 429.495n 0.0v 429.505n 0.0v 439.495n 0.0v 439.505n 0.0v 449.495n 0.0v 449.505n 0.0v 459.495n 0.0v 459.505n 0.0v 469.495n 0.0v 469.505n 0.0v 479.495n 0.0v 479.505n 0.0v 489.495n 0.0v 489.505n 0.0v 499.495n 0.0v 499.505n 0.0v 509.495n 0.0v 509.505n 0.0v 519.495n 0.0v 519.505n 0.0v 529.495n 0.0v 529.505n 0.0v 539.495n 0.0v 539.505n 1.8v 549.495n 1.8v 549.505n 1.8v 559.495n 1.8v 559.505n 1.8v 569.495n 1.8v 569.505n 1.8v 579.495n 1.8v 579.505n 0.0v 589.495n 0.0v 589.505n 0.0v 599.495n 0.0v 599.505n 0.0v 609.495n 0.0v 609.505n 0.0v 619.495n 0.0v 619.505n 0.0v 629.495n 0.0v 629.505n 0.0v 639.495n 0.0v 639.505n 0.0v 649.495n 0.0v 649.505n 0.0v 659.495n 0.0v 659.505n 1.8v 669.495n 1.8v 669.505n 0.0v 679.495n 0.0v 679.505n 0.0v 689.495n 0.0v 689.505n 0.0v 699.495n 0.0v 699.505n 1.8v 709.495n 1.8v 709.505n 1.8v 719.495n 1.8v 719.505n 1.8v 729.495n 1.8v 729.505n 0.0v 739.495n 0.0v 739.505n 0.0v 749.495n 0.0v 749.505n 0.0v 759.495n 0.0v 759.505n 1.8v 769.495n 1.8v 769.505n 1.8v 779.495n 1.8v 779.505n 0.0v 789.495n 0.0v 789.505n 0.0v 799.495n 0.0v 799.505n 1.8v 809.495n 1.8v 809.505n 1.8v 819.495n 1.8v 819.505n 1.8v 829.495n 1.8v 829.505n 1.8v 839.495n 1.8v 839.505n 1.8v 849.495n 1.8v 849.505n 1.8v 859.495n 1.8v 859.505n 1.8v 869.495n 1.8v 869.505n 1.8v 879.495n 1.8v 879.505n 1.8v 889.495n 1.8v 889.505n 1.8v 899.495n 1.8v 899.505n 1.8v 909.495n 1.8v 909.505n 1.8v 919.495n 1.8v 919.505n 0.0v 929.495n 0.0v 929.505n 0.0v 939.495n 0.0v 939.505n 0.0v 949.495n 0.0v 949.505n 0.0v 959.495n 0.0v 959.505n 0.0v 969.495n 0.0v 969.505n 0.0v 979.495n 0.0v 979.505n 0.0v 989.495n 0.0v 989.505n 0.0v 999.495n 0.0v 999.505n 1.8v 1009.495n 1.8v 1009.505n 1.8v 1019.495n 1.8v 1019.505n 1.8v 1029.495n 1.8v 1029.505n 1.8v 1039.495n 1.8v 1039.505n 1.8v 1049.495n 1.8v 1049.505n 1.8v 1059.495n 1.8v 1059.505n 1.8v 1069.495n 1.8v 1069.505n 1.8v 1079.495n 1.8v 1079.505n 1.8v 1089.495n 1.8v 1089.505n 1.8v 1099.495n 1.8v 1099.505n 1.8v 1109.495n 1.8v 1109.505n 1.8v 1119.495n 1.8v 1119.505n 1.8v 1129.495n 1.8v 1129.505n 1.8v 1139.495n 1.8v 1139.505n 0.0v 1149.495n 0.0v 1149.505n 0.0v 1159.495n 0.0v 1159.505n 0.0v 1169.495n 0.0v 1169.505n 0.0v 1179.495n 0.0v 1179.505n 0.0v 1189.495n 0.0v 1189.505n 0.0v 1199.495n 0.0v 1199.505n 0.0v 1209.495n 0.0v 1209.505n 0.0v 1219.495n 0.0v 1219.505n 0.0v 1229.495n 0.0v 1229.505n 1.8v 1239.495n 1.8v 1239.505n 0.0v 1249.495n 0.0v 1249.505n 0.0v 1259.495n 0.0v 1259.505n 0.0v 1269.495n 0.0v 1269.505n 1.8v 1279.495n 1.8v 1279.505n 1.8v 1289.495n 1.8v 1289.505n 1.8v 1299.495n 1.8v 1299.505n 1.8v 1309.495n 1.8v 1309.505n 1.8v 1319.495n 1.8v 1319.505n 1.8v 1329.495n 1.8v 1329.505n 1.8v 1339.495n 1.8v 1339.505n 1.8v 1349.495n 1.8v 1349.505n 0.0v 1359.495n 0.0v 1359.505n 0.0v 1369.495n 0.0v 1369.505n 1.8v 1379.495n 1.8v 1379.505n 1.8v 1389.495n 1.8v 1389.505n 1.8v 1399.495n 1.8v 1399.505n 1.8v 1409.495n 1.8v 1409.505n 1.8v 1419.495n 1.8v 1419.505n 1.8v 1429.495n 1.8v 1429.505n 1.8v 1439.495n 1.8v 1439.505n 0.0v 1449.495n 0.0v 1449.505n 0.0v 1459.495n 0.0v 1459.505n 0.0v 1469.495n 0.0v 1469.505n 1.8v 1479.495n 1.8v 1479.505n 1.8v 1489.495n 1.8v 1489.505n 1.8v 1499.495n 1.8v 1499.505n 1.8v 1509.495n 1.8v 1509.505n 1.8v 1519.495n 1.8v 1519.505n 1.8v 1529.495n 1.8v 1529.505n 1.8v 1539.495n 1.8v 1539.505n 1.8v 1549.495n 1.8v 1549.505n 0.0v 1559.495n 0.0v 1559.505n 1.8v 1569.495n 1.8v 1569.505n 1.8v 1579.495n 1.8v 1579.505n 1.8v 1589.495n 1.8v 1589.505n 1.8v 1599.495n 1.8v 1599.505n 1.8v 1609.495n 1.8v 1609.505n 1.8v 1619.495n 1.8v 1619.505n 1.8v 1629.495n 1.8v 1629.505n 1.8v 1639.495n 1.8v 1639.505n 1.8v 1649.495n 1.8v 1649.505n 1.8v 1659.495n 1.8v 1659.505n 1.8v 1669.495n 1.8v 1669.505n 1.8v 1679.495n 1.8v 1679.505n 1.8v 1689.495n 1.8v 1689.505n 1.8v 1699.495n 1.8v 1699.505n 1.8v 1709.495n 1.8v 1709.505n 1.8v 1719.495n 1.8v 1719.505n 0.0v 1729.495n 0.0v 1729.505n 0.0v 1739.495n 0.0v 1739.505n 0.0v 1749.495n 0.0v 1749.505n 0.0v 1759.495n 0.0v 1759.505n 0.0v 1769.495n 0.0v 1769.505n 0.0v 1779.495n 0.0v 1779.505n 0.0v 1789.495n 0.0v 1789.505n 1.8v 1799.495n 1.8v 1799.505n 0.0v 1809.495n 0.0v 1809.505n 1.8v 1819.495n 1.8v 1819.505n 1.8v 1829.495n 1.8v 1829.505n 1.8v 1839.495n 1.8v 1839.505n 1.8v 1849.495n 1.8v 1849.505n 1.8v 1859.495n 1.8v 1859.505n 1.8v 1869.495n 1.8v 1869.505n 1.8v 1879.495n 1.8v 1879.505n 1.8v 1889.495n 1.8v 1889.505n 1.8v 1899.495n 1.8v 1899.505n 1.8v 1909.495n 1.8v 1909.505n 1.8v 1919.495n 1.8v 1919.505n 1.8v 1929.495n 1.8v 1929.505n 1.8v 1939.495n 1.8v 1939.505n 1.8v 1949.495n 1.8v 1949.505n 1.8v 1959.495n 1.8v 1959.505n 1.8v 1969.495n 1.8v 1969.505n 1.8v 1979.495n 1.8v 1979.505n 0.0v 1989.495n 0.0v 1989.505n 0.0v 1999.495n 0.0v 1999.505n 0.0v 2009.495n 0.0v 2009.505n 0.0v 2019.495n 0.0v 2019.505n 0.0v 2029.495n 0.0v 2029.505n 0.0v 2039.495n 0.0v 2039.505n 0.0v 2049.495n 0.0v 2049.505n 0.0v )
* (time, data): [(0, 0), (10, 0), (20, 1), (30, 1), (40, 1), (50, 1), (60, 0), (70, 0), (80, 0), (90, 0), (100, 0), (110, 0), (120, 0), (130, 0), (140, 0), (150, 0), (160, 0), (170, 0), (180, 0), (190, 0), (200, 0), (210, 0), (220, 0), (230, 0), (240, 0), (250, 0), (260, 0), (270, 0), (280, 0), (290, 0), (300, 0), (310, 0), (320, 1), (330, 1), (340, 1), (350, 1), (360, 0), (370, 0), (380, 1), (390, 1), (400, 1), (410, 0), (420, 0), (430, 0), (440, 1), (450, 1), (460, 1), (470, 1), (480, 1), (490, 0), (500, 0), (510, 1), (520, 1), (530, 1), (540, 1), (550, 1), (560, 1), (570, 1), (580, 1), (590, 0), (600, 0), (610, 0), (620, 0), (630, 1), (640, 1), (650, 1), (660, 1), (670, 1), (680, 1), (690, 1), (700, 0), (710, 0), (720, 0), (730, 1), (740, 0), (750, 0), (760, 1), (770, 1), (780, 0), (790, 0), (800, 1), (810, 1), (820, 1), (830, 1), (840, 1), (850, 1), (860, 1), (870, 0), (880, 0), (890, 0), (900, 0), (910, 0), (920, 1), (930, 1), (940, 1), (950, 1), (960, 1), (970, 1), (980, 0), (990, 0), (1000, 1), (1010, 1), (1020, 1), (1030, 1), (1040, 1), (1050, 1), (1060, 1), (1070, 1), (1080, 1), (1090, 1), (1100, 1), (1110, 1), (1120, 1), (1130, 1), (1140, 0), (1150, 0), (1160, 0), (1170, 0), (1180, 0), (1190, 0), (1200, 1), (1210, 1), (1220, 1), (1230, 0), (1240, 0), (1250, 0), (1260, 0), (1270, 0), (1280, 0), (1290, 0), (1300, 0), (1310, 0), (1320, 0), (1330, 0), (1340, 1), (1350, 1), (1360, 1), (1370, 1), (1380, 1), (1390, 1), (1400, 1), (1410, 1), (1420, 1), (1430, 1), (1440, 0), (1450, 0), (1460, 1), (1470, 1), (1480, 1), (1490, 1), (1500, 1), (1510, 1), (1520, 1), (1530, 1), (1540, 1), (1550, 1), (1560, 1), (1570, 1), (1580, 1), (1590, 0), (1600, 0), (1610, 0), (1620, 0), (1630, 0), (1640, 1), (1650, 1), (1660, 1), (1670, 1), (1680, 1), (1690, 1), (1700, 1), (1710, 1), (1720, 1), (1730, 1), (1740, 1), (1750, 1), (1760, 1), (1770, 0), (1780, 0), (1790, 1), (1800, 1), (1810, 0), (1820, 0), (1830, 0), (1840, 0), (1850, 0), (1860, 0), (1870, 0), (1880, 0), (1890, 0), (1900, 1), (1910, 0), (1920, 0), (1930, 0), (1940, 0), (1950, 0), (1960, 0), (1970, 0), (1980, 1), (1990, 1), (2000, 1), (2010, 0), (2020, 0), (2030, 0), (2040, 0), (2050, 0)]
Vdin0_17  din0_17  0 PWL (0n 0.0v 9.495n 0.0v 9.505n 0.0v 19.495n 0.0v 19.505n 1.8v 29.495n 1.8v 29.505n 1.8v 39.495n 1.8v 39.505n 1.8v 49.495n 1.8v 49.505n 1.8v 59.495n 1.8v 59.505n 0.0v 69.495n 0.0v 69.505n 0.0v 79.495n 0.0v 79.505n 0.0v 89.495n 0.0v 89.505n 0.0v 99.495n 0.0v 99.505n 0.0v 109.495n 0.0v 109.505n 0.0v 119.495n 0.0v 119.505n 0.0v 129.495n 0.0v 129.505n 0.0v 139.495n 0.0v 139.505n 0.0v 149.495n 0.0v 149.505n 0.0v 159.495n 0.0v 159.505n 0.0v 169.495n 0.0v 169.505n 0.0v 179.495n 0.0v 179.505n 0.0v 189.495n 0.0v 189.505n 0.0v 199.495n 0.0v 199.505n 0.0v 209.495n 0.0v 209.505n 0.0v 219.495n 0.0v 219.505n 0.0v 229.495n 0.0v 229.505n 0.0v 239.495n 0.0v 239.505n 0.0v 249.495n 0.0v 249.505n 0.0v 259.495n 0.0v 259.505n 0.0v 269.495n 0.0v 269.505n 0.0v 279.495n 0.0v 279.505n 0.0v 289.495n 0.0v 289.505n 0.0v 299.495n 0.0v 299.505n 0.0v 309.495n 0.0v 309.505n 0.0v 319.495n 0.0v 319.505n 1.8v 329.495n 1.8v 329.505n 1.8v 339.495n 1.8v 339.505n 1.8v 349.495n 1.8v 349.505n 1.8v 359.495n 1.8v 359.505n 0.0v 369.495n 0.0v 369.505n 0.0v 379.495n 0.0v 379.505n 1.8v 389.495n 1.8v 389.505n 1.8v 399.495n 1.8v 399.505n 1.8v 409.495n 1.8v 409.505n 0.0v 419.495n 0.0v 419.505n 0.0v 429.495n 0.0v 429.505n 0.0v 439.495n 0.0v 439.505n 1.8v 449.495n 1.8v 449.505n 1.8v 459.495n 1.8v 459.505n 1.8v 469.495n 1.8v 469.505n 1.8v 479.495n 1.8v 479.505n 1.8v 489.495n 1.8v 489.505n 0.0v 499.495n 0.0v 499.505n 0.0v 509.495n 0.0v 509.505n 1.8v 519.495n 1.8v 519.505n 1.8v 529.495n 1.8v 529.505n 1.8v 539.495n 1.8v 539.505n 1.8v 549.495n 1.8v 549.505n 1.8v 559.495n 1.8v 559.505n 1.8v 569.495n 1.8v 569.505n 1.8v 579.495n 1.8v 579.505n 1.8v 589.495n 1.8v 589.505n 0.0v 599.495n 0.0v 599.505n 0.0v 609.495n 0.0v 609.505n 0.0v 619.495n 0.0v 619.505n 0.0v 629.495n 0.0v 629.505n 1.8v 639.495n 1.8v 639.505n 1.8v 649.495n 1.8v 649.505n 1.8v 659.495n 1.8v 659.505n 1.8v 669.495n 1.8v 669.505n 1.8v 679.495n 1.8v 679.505n 1.8v 689.495n 1.8v 689.505n 1.8v 699.495n 1.8v 699.505n 0.0v 709.495n 0.0v 709.505n 0.0v 719.495n 0.0v 719.505n 0.0v 729.495n 0.0v 729.505n 1.8v 739.495n 1.8v 739.505n 0.0v 749.495n 0.0v 749.505n 0.0v 759.495n 0.0v 759.505n 1.8v 769.495n 1.8v 769.505n 1.8v 779.495n 1.8v 779.505n 0.0v 789.495n 0.0v 789.505n 0.0v 799.495n 0.0v 799.505n 1.8v 809.495n 1.8v 809.505n 1.8v 819.495n 1.8v 819.505n 1.8v 829.495n 1.8v 829.505n 1.8v 839.495n 1.8v 839.505n 1.8v 849.495n 1.8v 849.505n 1.8v 859.495n 1.8v 859.505n 1.8v 869.495n 1.8v 869.505n 0.0v 879.495n 0.0v 879.505n 0.0v 889.495n 0.0v 889.505n 0.0v 899.495n 0.0v 899.505n 0.0v 909.495n 0.0v 909.505n 0.0v 919.495n 0.0v 919.505n 1.8v 929.495n 1.8v 929.505n 1.8v 939.495n 1.8v 939.505n 1.8v 949.495n 1.8v 949.505n 1.8v 959.495n 1.8v 959.505n 1.8v 969.495n 1.8v 969.505n 1.8v 979.495n 1.8v 979.505n 0.0v 989.495n 0.0v 989.505n 0.0v 999.495n 0.0v 999.505n 1.8v 1009.495n 1.8v 1009.505n 1.8v 1019.495n 1.8v 1019.505n 1.8v 1029.495n 1.8v 1029.505n 1.8v 1039.495n 1.8v 1039.505n 1.8v 1049.495n 1.8v 1049.505n 1.8v 1059.495n 1.8v 1059.505n 1.8v 1069.495n 1.8v 1069.505n 1.8v 1079.495n 1.8v 1079.505n 1.8v 1089.495n 1.8v 1089.505n 1.8v 1099.495n 1.8v 1099.505n 1.8v 1109.495n 1.8v 1109.505n 1.8v 1119.495n 1.8v 1119.505n 1.8v 1129.495n 1.8v 1129.505n 1.8v 1139.495n 1.8v 1139.505n 0.0v 1149.495n 0.0v 1149.505n 0.0v 1159.495n 0.0v 1159.505n 0.0v 1169.495n 0.0v 1169.505n 0.0v 1179.495n 0.0v 1179.505n 0.0v 1189.495n 0.0v 1189.505n 0.0v 1199.495n 0.0v 1199.505n 1.8v 1209.495n 1.8v 1209.505n 1.8v 1219.495n 1.8v 1219.505n 1.8v 1229.495n 1.8v 1229.505n 0.0v 1239.495n 0.0v 1239.505n 0.0v 1249.495n 0.0v 1249.505n 0.0v 1259.495n 0.0v 1259.505n 0.0v 1269.495n 0.0v 1269.505n 0.0v 1279.495n 0.0v 1279.505n 0.0v 1289.495n 0.0v 1289.505n 0.0v 1299.495n 0.0v 1299.505n 0.0v 1309.495n 0.0v 1309.505n 0.0v 1319.495n 0.0v 1319.505n 0.0v 1329.495n 0.0v 1329.505n 0.0v 1339.495n 0.0v 1339.505n 1.8v 1349.495n 1.8v 1349.505n 1.8v 1359.495n 1.8v 1359.505n 1.8v 1369.495n 1.8v 1369.505n 1.8v 1379.495n 1.8v 1379.505n 1.8v 1389.495n 1.8v 1389.505n 1.8v 1399.495n 1.8v 1399.505n 1.8v 1409.495n 1.8v 1409.505n 1.8v 1419.495n 1.8v 1419.505n 1.8v 1429.495n 1.8v 1429.505n 1.8v 1439.495n 1.8v 1439.505n 0.0v 1449.495n 0.0v 1449.505n 0.0v 1459.495n 0.0v 1459.505n 1.8v 1469.495n 1.8v 1469.505n 1.8v 1479.495n 1.8v 1479.505n 1.8v 1489.495n 1.8v 1489.505n 1.8v 1499.495n 1.8v 1499.505n 1.8v 1509.495n 1.8v 1509.505n 1.8v 1519.495n 1.8v 1519.505n 1.8v 1529.495n 1.8v 1529.505n 1.8v 1539.495n 1.8v 1539.505n 1.8v 1549.495n 1.8v 1549.505n 1.8v 1559.495n 1.8v 1559.505n 1.8v 1569.495n 1.8v 1569.505n 1.8v 1579.495n 1.8v 1579.505n 1.8v 1589.495n 1.8v 1589.505n 0.0v 1599.495n 0.0v 1599.505n 0.0v 1609.495n 0.0v 1609.505n 0.0v 1619.495n 0.0v 1619.505n 0.0v 1629.495n 0.0v 1629.505n 0.0v 1639.495n 0.0v 1639.505n 1.8v 1649.495n 1.8v 1649.505n 1.8v 1659.495n 1.8v 1659.505n 1.8v 1669.495n 1.8v 1669.505n 1.8v 1679.495n 1.8v 1679.505n 1.8v 1689.495n 1.8v 1689.505n 1.8v 1699.495n 1.8v 1699.505n 1.8v 1709.495n 1.8v 1709.505n 1.8v 1719.495n 1.8v 1719.505n 1.8v 1729.495n 1.8v 1729.505n 1.8v 1739.495n 1.8v 1739.505n 1.8v 1749.495n 1.8v 1749.505n 1.8v 1759.495n 1.8v 1759.505n 1.8v 1769.495n 1.8v 1769.505n 0.0v 1779.495n 0.0v 1779.505n 0.0v 1789.495n 0.0v 1789.505n 1.8v 1799.495n 1.8v 1799.505n 1.8v 1809.495n 1.8v 1809.505n 0.0v 1819.495n 0.0v 1819.505n 0.0v 1829.495n 0.0v 1829.505n 0.0v 1839.495n 0.0v 1839.505n 0.0v 1849.495n 0.0v 1849.505n 0.0v 1859.495n 0.0v 1859.505n 0.0v 1869.495n 0.0v 1869.505n 0.0v 1879.495n 0.0v 1879.505n 0.0v 1889.495n 0.0v 1889.505n 0.0v 1899.495n 0.0v 1899.505n 1.8v 1909.495n 1.8v 1909.505n 0.0v 1919.495n 0.0v 1919.505n 0.0v 1929.495n 0.0v 1929.505n 0.0v 1939.495n 0.0v 1939.505n 0.0v 1949.495n 0.0v 1949.505n 0.0v 1959.495n 0.0v 1959.505n 0.0v 1969.495n 0.0v 1969.505n 0.0v 1979.495n 0.0v 1979.505n 1.8v 1989.495n 1.8v 1989.505n 1.8v 1999.495n 1.8v 1999.505n 1.8v 2009.495n 1.8v 2009.505n 0.0v 2019.495n 0.0v 2019.505n 0.0v 2029.495n 0.0v 2029.505n 0.0v 2039.495n 0.0v 2039.505n 0.0v 2049.495n 0.0v 2049.505n 0.0v )
* (time, data): [(0, 0), (10, 1), (20, 0), (30, 1), (40, 1), (50, 1), (60, 0), (70, 0), (80, 0), (90, 1), (100, 1), (110, 1), (120, 0), (130, 0), (140, 0), (150, 0), (160, 0), (170, 0), (180, 0), (190, 0), (200, 1), (210, 1), (220, 1), (230, 1), (240, 1), (250, 1), (260, 1), (270, 1), (280, 1), (290, 1), (300, 1), (310, 1), (320, 1), (330, 1), (340, 1), (350, 1), (360, 0), (370, 0), (380, 1), (390, 1), (400, 1), (410, 1), (420, 0), (430, 0), (440, 1), (450, 1), (460, 1), (470, 1), (480, 1), (490, 0), (500, 0), (510, 0), (520, 0), (530, 0), (540, 0), (550, 0), (560, 0), (570, 0), (580, 0), (590, 1), (600, 1), (610, 1), (620, 1), (630, 1), (640, 1), (650, 1), (660, 0), (670, 1), (680, 1), (690, 1), (700, 1), (710, 1), (720, 1), (730, 0), (740, 0), (750, 0), (760, 0), (770, 1), (780, 0), (790, 0), (800, 1), (810, 1), (820, 1), (830, 1), (840, 0), (850, 0), (860, 0), (870, 1), (880, 1), (890, 1), (900, 1), (910, 1), (920, 0), (930, 0), (940, 0), (950, 0), (960, 0), (970, 0), (980, 1), (990, 1), (1000, 0), (1010, 0), (1020, 0), (1030, 0), (1040, 0), (1050, 0), (1060, 0), (1070, 0), (1080, 0), (1090, 0), (1100, 0), (1110, 0), (1120, 1), (1130, 1), (1140, 1), (1150, 1), (1160, 1), (1170, 0), (1180, 0), (1190, 0), (1200, 1), (1210, 1), (1220, 1), (1230, 1), (1240, 0), (1250, 0), (1260, 0), (1270, 1), (1280, 1), (1290, 1), (1300, 1), (1310, 1), (1320, 0), (1330, 1), (1340, 0), (1350, 0), (1360, 0), (1370, 1), (1380, 1), (1390, 1), (1400, 1), (1410, 1), (1420, 1), (1430, 1), (1440, 1), (1450, 1), (1460, 0), (1470, 1), (1480, 1), (1490, 1), (1500, 1), (1510, 1), (1520, 1), (1530, 1), (1540, 1), (1550, 1), (1560, 1), (1570, 1), (1580, 1), (1590, 1), (1600, 1), (1610, 1), (1620, 1), (1630, 1), (1640, 1), (1650, 1), (1660, 1), (1670, 1), (1680, 1), (1690, 1), (1700, 1), (1710, 1), (1720, 0), (1730, 0), (1740, 0), (1750, 0), (1760, 0), (1770, 0), (1780, 1), (1790, 1), (1800, 0), (1810, 0), (1820, 0), (1830, 0), (1840, 0), (1850, 0), (1860, 0), (1870, 0), (1880, 0), (1890, 0), (1900, 0), (1910, 0), (1920, 0), (1930, 0), (1940, 0), (1950, 0), (1960, 0), (1970, 0), (1980, 1), (1990, 1), (2000, 1), (2010, 1), (2020, 1), (2030, 1), (2040, 1), (2050, 1)]
Vdin0_18  din0_18  0 PWL (0n 0.0v 9.495n 0.0v 9.505n 1.8v 19.495n 1.8v 19.505n 0.0v 29.495n 0.0v 29.505n 1.8v 39.495n 1.8v 39.505n 1.8v 49.495n 1.8v 49.505n 1.8v 59.495n 1.8v 59.505n 0.0v 69.495n 0.0v 69.505n 0.0v 79.495n 0.0v 79.505n 0.0v 89.495n 0.0v 89.505n 1.8v 99.495n 1.8v 99.505n 1.8v 109.495n 1.8v 109.505n 1.8v 119.495n 1.8v 119.505n 0.0v 129.495n 0.0v 129.505n 0.0v 139.495n 0.0v 139.505n 0.0v 149.495n 0.0v 149.505n 0.0v 159.495n 0.0v 159.505n 0.0v 169.495n 0.0v 169.505n 0.0v 179.495n 0.0v 179.505n 0.0v 189.495n 0.0v 189.505n 0.0v 199.495n 0.0v 199.505n 1.8v 209.495n 1.8v 209.505n 1.8v 219.495n 1.8v 219.505n 1.8v 229.495n 1.8v 229.505n 1.8v 239.495n 1.8v 239.505n 1.8v 249.495n 1.8v 249.505n 1.8v 259.495n 1.8v 259.505n 1.8v 269.495n 1.8v 269.505n 1.8v 279.495n 1.8v 279.505n 1.8v 289.495n 1.8v 289.505n 1.8v 299.495n 1.8v 299.505n 1.8v 309.495n 1.8v 309.505n 1.8v 319.495n 1.8v 319.505n 1.8v 329.495n 1.8v 329.505n 1.8v 339.495n 1.8v 339.505n 1.8v 349.495n 1.8v 349.505n 1.8v 359.495n 1.8v 359.505n 0.0v 369.495n 0.0v 369.505n 0.0v 379.495n 0.0v 379.505n 1.8v 389.495n 1.8v 389.505n 1.8v 399.495n 1.8v 399.505n 1.8v 409.495n 1.8v 409.505n 1.8v 419.495n 1.8v 419.505n 0.0v 429.495n 0.0v 429.505n 0.0v 439.495n 0.0v 439.505n 1.8v 449.495n 1.8v 449.505n 1.8v 459.495n 1.8v 459.505n 1.8v 469.495n 1.8v 469.505n 1.8v 479.495n 1.8v 479.505n 1.8v 489.495n 1.8v 489.505n 0.0v 499.495n 0.0v 499.505n 0.0v 509.495n 0.0v 509.505n 0.0v 519.495n 0.0v 519.505n 0.0v 529.495n 0.0v 529.505n 0.0v 539.495n 0.0v 539.505n 0.0v 549.495n 0.0v 549.505n 0.0v 559.495n 0.0v 559.505n 0.0v 569.495n 0.0v 569.505n 0.0v 579.495n 0.0v 579.505n 0.0v 589.495n 0.0v 589.505n 1.8v 599.495n 1.8v 599.505n 1.8v 609.495n 1.8v 609.505n 1.8v 619.495n 1.8v 619.505n 1.8v 629.495n 1.8v 629.505n 1.8v 639.495n 1.8v 639.505n 1.8v 649.495n 1.8v 649.505n 1.8v 659.495n 1.8v 659.505n 0.0v 669.495n 0.0v 669.505n 1.8v 679.495n 1.8v 679.505n 1.8v 689.495n 1.8v 689.505n 1.8v 699.495n 1.8v 699.505n 1.8v 709.495n 1.8v 709.505n 1.8v 719.495n 1.8v 719.505n 1.8v 729.495n 1.8v 729.505n 0.0v 739.495n 0.0v 739.505n 0.0v 749.495n 0.0v 749.505n 0.0v 759.495n 0.0v 759.505n 0.0v 769.495n 0.0v 769.505n 1.8v 779.495n 1.8v 779.505n 0.0v 789.495n 0.0v 789.505n 0.0v 799.495n 0.0v 799.505n 1.8v 809.495n 1.8v 809.505n 1.8v 819.495n 1.8v 819.505n 1.8v 829.495n 1.8v 829.505n 1.8v 839.495n 1.8v 839.505n 0.0v 849.495n 0.0v 849.505n 0.0v 859.495n 0.0v 859.505n 0.0v 869.495n 0.0v 869.505n 1.8v 879.495n 1.8v 879.505n 1.8v 889.495n 1.8v 889.505n 1.8v 899.495n 1.8v 899.505n 1.8v 909.495n 1.8v 909.505n 1.8v 919.495n 1.8v 919.505n 0.0v 929.495n 0.0v 929.505n 0.0v 939.495n 0.0v 939.505n 0.0v 949.495n 0.0v 949.505n 0.0v 959.495n 0.0v 959.505n 0.0v 969.495n 0.0v 969.505n 0.0v 979.495n 0.0v 979.505n 1.8v 989.495n 1.8v 989.505n 1.8v 999.495n 1.8v 999.505n 0.0v 1009.495n 0.0v 1009.505n 0.0v 1019.495n 0.0v 1019.505n 0.0v 1029.495n 0.0v 1029.505n 0.0v 1039.495n 0.0v 1039.505n 0.0v 1049.495n 0.0v 1049.505n 0.0v 1059.495n 0.0v 1059.505n 0.0v 1069.495n 0.0v 1069.505n 0.0v 1079.495n 0.0v 1079.505n 0.0v 1089.495n 0.0v 1089.505n 0.0v 1099.495n 0.0v 1099.505n 0.0v 1109.495n 0.0v 1109.505n 0.0v 1119.495n 0.0v 1119.505n 1.8v 1129.495n 1.8v 1129.505n 1.8v 1139.495n 1.8v 1139.505n 1.8v 1149.495n 1.8v 1149.505n 1.8v 1159.495n 1.8v 1159.505n 1.8v 1169.495n 1.8v 1169.505n 0.0v 1179.495n 0.0v 1179.505n 0.0v 1189.495n 0.0v 1189.505n 0.0v 1199.495n 0.0v 1199.505n 1.8v 1209.495n 1.8v 1209.505n 1.8v 1219.495n 1.8v 1219.505n 1.8v 1229.495n 1.8v 1229.505n 1.8v 1239.495n 1.8v 1239.505n 0.0v 1249.495n 0.0v 1249.505n 0.0v 1259.495n 0.0v 1259.505n 0.0v 1269.495n 0.0v 1269.505n 1.8v 1279.495n 1.8v 1279.505n 1.8v 1289.495n 1.8v 1289.505n 1.8v 1299.495n 1.8v 1299.505n 1.8v 1309.495n 1.8v 1309.505n 1.8v 1319.495n 1.8v 1319.505n 0.0v 1329.495n 0.0v 1329.505n 1.8v 1339.495n 1.8v 1339.505n 0.0v 1349.495n 0.0v 1349.505n 0.0v 1359.495n 0.0v 1359.505n 0.0v 1369.495n 0.0v 1369.505n 1.8v 1379.495n 1.8v 1379.505n 1.8v 1389.495n 1.8v 1389.505n 1.8v 1399.495n 1.8v 1399.505n 1.8v 1409.495n 1.8v 1409.505n 1.8v 1419.495n 1.8v 1419.505n 1.8v 1429.495n 1.8v 1429.505n 1.8v 1439.495n 1.8v 1439.505n 1.8v 1449.495n 1.8v 1449.505n 1.8v 1459.495n 1.8v 1459.505n 0.0v 1469.495n 0.0v 1469.505n 1.8v 1479.495n 1.8v 1479.505n 1.8v 1489.495n 1.8v 1489.505n 1.8v 1499.495n 1.8v 1499.505n 1.8v 1509.495n 1.8v 1509.505n 1.8v 1519.495n 1.8v 1519.505n 1.8v 1529.495n 1.8v 1529.505n 1.8v 1539.495n 1.8v 1539.505n 1.8v 1549.495n 1.8v 1549.505n 1.8v 1559.495n 1.8v 1559.505n 1.8v 1569.495n 1.8v 1569.505n 1.8v 1579.495n 1.8v 1579.505n 1.8v 1589.495n 1.8v 1589.505n 1.8v 1599.495n 1.8v 1599.505n 1.8v 1609.495n 1.8v 1609.505n 1.8v 1619.495n 1.8v 1619.505n 1.8v 1629.495n 1.8v 1629.505n 1.8v 1639.495n 1.8v 1639.505n 1.8v 1649.495n 1.8v 1649.505n 1.8v 1659.495n 1.8v 1659.505n 1.8v 1669.495n 1.8v 1669.505n 1.8v 1679.495n 1.8v 1679.505n 1.8v 1689.495n 1.8v 1689.505n 1.8v 1699.495n 1.8v 1699.505n 1.8v 1709.495n 1.8v 1709.505n 1.8v 1719.495n 1.8v 1719.505n 0.0v 1729.495n 0.0v 1729.505n 0.0v 1739.495n 0.0v 1739.505n 0.0v 1749.495n 0.0v 1749.505n 0.0v 1759.495n 0.0v 1759.505n 0.0v 1769.495n 0.0v 1769.505n 0.0v 1779.495n 0.0v 1779.505n 1.8v 1789.495n 1.8v 1789.505n 1.8v 1799.495n 1.8v 1799.505n 0.0v 1809.495n 0.0v 1809.505n 0.0v 1819.495n 0.0v 1819.505n 0.0v 1829.495n 0.0v 1829.505n 0.0v 1839.495n 0.0v 1839.505n 0.0v 1849.495n 0.0v 1849.505n 0.0v 1859.495n 0.0v 1859.505n 0.0v 1869.495n 0.0v 1869.505n 0.0v 1879.495n 0.0v 1879.505n 0.0v 1889.495n 0.0v 1889.505n 0.0v 1899.495n 0.0v 1899.505n 0.0v 1909.495n 0.0v 1909.505n 0.0v 1919.495n 0.0v 1919.505n 0.0v 1929.495n 0.0v 1929.505n 0.0v 1939.495n 0.0v 1939.505n 0.0v 1949.495n 0.0v 1949.505n 0.0v 1959.495n 0.0v 1959.505n 0.0v 1969.495n 0.0v 1969.505n 0.0v 1979.495n 0.0v 1979.505n 1.8v 1989.495n 1.8v 1989.505n 1.8v 1999.495n 1.8v 1999.505n 1.8v 2009.495n 1.8v 2009.505n 1.8v 2019.495n 1.8v 2019.505n 1.8v 2029.495n 1.8v 2029.505n 1.8v 2039.495n 1.8v 2039.505n 1.8v 2049.495n 1.8v 2049.505n 1.8v )
* (time, data): [(0, 0), (10, 1), (20, 0), (30, 0), (40, 0), (50, 0), (60, 1), (70, 1), (80, 1), (90, 1), (100, 1), (110, 1), (120, 1), (130, 1), (140, 1), (150, 1), (160, 1), (170, 1), (180, 1), (190, 1), (200, 1), (210, 1), (220, 1), (230, 1), (240, 1), (250, 1), (260, 1), (270, 1), (280, 1), (290, 1), (300, 1), (310, 1), (320, 1), (330, 1), (340, 1), (350, 1), (360, 0), (370, 0), (380, 0), (390, 0), (400, 0), (410, 0), (420, 1), (430, 1), (440, 0), (450, 0), (460, 0), (470, 0), (480, 0), (490, 1), (500, 1), (510, 0), (520, 0), (530, 1), (540, 1), (550, 1), (560, 1), (570, 1), (580, 1), (590, 1), (600, 1), (610, 1), (620, 1), (630, 0), (640, 0), (650, 0), (660, 0), (670, 0), (680, 0), (690, 0), (700, 0), (710, 0), (720, 0), (730, 0), (740, 1), (750, 1), (760, 1), (770, 1), (780, 0), (790, 0), (800, 0), (810, 0), (820, 0), (830, 0), (840, 1), (850, 1), (860, 1), (870, 0), (880, 0), (890, 0), (900, 0), (910, 0), (920, 0), (930, 0), (940, 0), (950, 0), (960, 0), (970, 1), (980, 1), (990, 1), (1000, 1), (1010, 1), (1020, 0), (1030, 0), (1040, 0), (1050, 0), (1060, 0), (1070, 0), (1080, 0), (1090, 0), (1100, 0), (1110, 0), (1120, 0), (1130, 0), (1140, 0), (1150, 0), (1160, 1), (1170, 1), (1180, 1), (1190, 1), (1200, 0), (1210, 0), (1220, 0), (1230, 1), (1240, 0), (1250, 1), (1260, 1), (1270, 0), (1280, 0), (1290, 0), (1300, 0), (1310, 0), (1320, 0), (1330, 0), (1340, 1), (1350, 1), (1360, 1), (1370, 1), (1380, 1), (1390, 1), (1400, 1), (1410, 1), (1420, 1), (1430, 1), (1440, 1), (1450, 1), (1460, 1), (1470, 1), (1480, 1), (1490, 1), (1500, 1), (1510, 1), (1520, 1), (1530, 1), (1540, 1), (1550, 0), (1560, 0), (1570, 0), (1580, 0), (1590, 0), (1600, 0), (1610, 0), (1620, 0), (1630, 0), (1640, 1), (1650, 1), (1660, 1), (1670, 1), (1680, 1), (1690, 1), (1700, 1), (1710, 1), (1720, 0), (1730, 0), (1740, 0), (1750, 0), (1760, 0), (1770, 1), (1780, 1), (1790, 0), (1800, 1), (1810, 1), (1820, 1), (1830, 1), (1840, 1), (1850, 1), (1860, 1), (1870, 1), (1880, 1), (1890, 1), (1900, 0), (1910, 1), (1920, 1), (1930, 0), (1940, 0), (1950, 0), (1960, 0), (1970, 0), (1980, 0), (1990, 0), (2000, 0), (2010, 1), (2020, 1), (2030, 1), (2040, 1), (2050, 1)]
Vdin0_19  din0_19  0 PWL (0n 0.0v 9.495n 0.0v 9.505n 1.8v 19.495n 1.8v 19.505n 0.0v 29.495n 0.0v 29.505n 0.0v 39.495n 0.0v 39.505n 0.0v 49.495n 0.0v 49.505n 0.0v 59.495n 0.0v 59.505n 1.8v 69.495n 1.8v 69.505n 1.8v 79.495n 1.8v 79.505n 1.8v 89.495n 1.8v 89.505n 1.8v 99.495n 1.8v 99.505n 1.8v 109.495n 1.8v 109.505n 1.8v 119.495n 1.8v 119.505n 1.8v 129.495n 1.8v 129.505n 1.8v 139.495n 1.8v 139.505n 1.8v 149.495n 1.8v 149.505n 1.8v 159.495n 1.8v 159.505n 1.8v 169.495n 1.8v 169.505n 1.8v 179.495n 1.8v 179.505n 1.8v 189.495n 1.8v 189.505n 1.8v 199.495n 1.8v 199.505n 1.8v 209.495n 1.8v 209.505n 1.8v 219.495n 1.8v 219.505n 1.8v 229.495n 1.8v 229.505n 1.8v 239.495n 1.8v 239.505n 1.8v 249.495n 1.8v 249.505n 1.8v 259.495n 1.8v 259.505n 1.8v 269.495n 1.8v 269.505n 1.8v 279.495n 1.8v 279.505n 1.8v 289.495n 1.8v 289.505n 1.8v 299.495n 1.8v 299.505n 1.8v 309.495n 1.8v 309.505n 1.8v 319.495n 1.8v 319.505n 1.8v 329.495n 1.8v 329.505n 1.8v 339.495n 1.8v 339.505n 1.8v 349.495n 1.8v 349.505n 1.8v 359.495n 1.8v 359.505n 0.0v 369.495n 0.0v 369.505n 0.0v 379.495n 0.0v 379.505n 0.0v 389.495n 0.0v 389.505n 0.0v 399.495n 0.0v 399.505n 0.0v 409.495n 0.0v 409.505n 0.0v 419.495n 0.0v 419.505n 1.8v 429.495n 1.8v 429.505n 1.8v 439.495n 1.8v 439.505n 0.0v 449.495n 0.0v 449.505n 0.0v 459.495n 0.0v 459.505n 0.0v 469.495n 0.0v 469.505n 0.0v 479.495n 0.0v 479.505n 0.0v 489.495n 0.0v 489.505n 1.8v 499.495n 1.8v 499.505n 1.8v 509.495n 1.8v 509.505n 0.0v 519.495n 0.0v 519.505n 0.0v 529.495n 0.0v 529.505n 1.8v 539.495n 1.8v 539.505n 1.8v 549.495n 1.8v 549.505n 1.8v 559.495n 1.8v 559.505n 1.8v 569.495n 1.8v 569.505n 1.8v 579.495n 1.8v 579.505n 1.8v 589.495n 1.8v 589.505n 1.8v 599.495n 1.8v 599.505n 1.8v 609.495n 1.8v 609.505n 1.8v 619.495n 1.8v 619.505n 1.8v 629.495n 1.8v 629.505n 0.0v 639.495n 0.0v 639.505n 0.0v 649.495n 0.0v 649.505n 0.0v 659.495n 0.0v 659.505n 0.0v 669.495n 0.0v 669.505n 0.0v 679.495n 0.0v 679.505n 0.0v 689.495n 0.0v 689.505n 0.0v 699.495n 0.0v 699.505n 0.0v 709.495n 0.0v 709.505n 0.0v 719.495n 0.0v 719.505n 0.0v 729.495n 0.0v 729.505n 0.0v 739.495n 0.0v 739.505n 1.8v 749.495n 1.8v 749.505n 1.8v 759.495n 1.8v 759.505n 1.8v 769.495n 1.8v 769.505n 1.8v 779.495n 1.8v 779.505n 0.0v 789.495n 0.0v 789.505n 0.0v 799.495n 0.0v 799.505n 0.0v 809.495n 0.0v 809.505n 0.0v 819.495n 0.0v 819.505n 0.0v 829.495n 0.0v 829.505n 0.0v 839.495n 0.0v 839.505n 1.8v 849.495n 1.8v 849.505n 1.8v 859.495n 1.8v 859.505n 1.8v 869.495n 1.8v 869.505n 0.0v 879.495n 0.0v 879.505n 0.0v 889.495n 0.0v 889.505n 0.0v 899.495n 0.0v 899.505n 0.0v 909.495n 0.0v 909.505n 0.0v 919.495n 0.0v 919.505n 0.0v 929.495n 0.0v 929.505n 0.0v 939.495n 0.0v 939.505n 0.0v 949.495n 0.0v 949.505n 0.0v 959.495n 0.0v 959.505n 0.0v 969.495n 0.0v 969.505n 1.8v 979.495n 1.8v 979.505n 1.8v 989.495n 1.8v 989.505n 1.8v 999.495n 1.8v 999.505n 1.8v 1009.495n 1.8v 1009.505n 1.8v 1019.495n 1.8v 1019.505n 0.0v 1029.495n 0.0v 1029.505n 0.0v 1039.495n 0.0v 1039.505n 0.0v 1049.495n 0.0v 1049.505n 0.0v 1059.495n 0.0v 1059.505n 0.0v 1069.495n 0.0v 1069.505n 0.0v 1079.495n 0.0v 1079.505n 0.0v 1089.495n 0.0v 1089.505n 0.0v 1099.495n 0.0v 1099.505n 0.0v 1109.495n 0.0v 1109.505n 0.0v 1119.495n 0.0v 1119.505n 0.0v 1129.495n 0.0v 1129.505n 0.0v 1139.495n 0.0v 1139.505n 0.0v 1149.495n 0.0v 1149.505n 0.0v 1159.495n 0.0v 1159.505n 1.8v 1169.495n 1.8v 1169.505n 1.8v 1179.495n 1.8v 1179.505n 1.8v 1189.495n 1.8v 1189.505n 1.8v 1199.495n 1.8v 1199.505n 0.0v 1209.495n 0.0v 1209.505n 0.0v 1219.495n 0.0v 1219.505n 0.0v 1229.495n 0.0v 1229.505n 1.8v 1239.495n 1.8v 1239.505n 0.0v 1249.495n 0.0v 1249.505n 1.8v 1259.495n 1.8v 1259.505n 1.8v 1269.495n 1.8v 1269.505n 0.0v 1279.495n 0.0v 1279.505n 0.0v 1289.495n 0.0v 1289.505n 0.0v 1299.495n 0.0v 1299.505n 0.0v 1309.495n 0.0v 1309.505n 0.0v 1319.495n 0.0v 1319.505n 0.0v 1329.495n 0.0v 1329.505n 0.0v 1339.495n 0.0v 1339.505n 1.8v 1349.495n 1.8v 1349.505n 1.8v 1359.495n 1.8v 1359.505n 1.8v 1369.495n 1.8v 1369.505n 1.8v 1379.495n 1.8v 1379.505n 1.8v 1389.495n 1.8v 1389.505n 1.8v 1399.495n 1.8v 1399.505n 1.8v 1409.495n 1.8v 1409.505n 1.8v 1419.495n 1.8v 1419.505n 1.8v 1429.495n 1.8v 1429.505n 1.8v 1439.495n 1.8v 1439.505n 1.8v 1449.495n 1.8v 1449.505n 1.8v 1459.495n 1.8v 1459.505n 1.8v 1469.495n 1.8v 1469.505n 1.8v 1479.495n 1.8v 1479.505n 1.8v 1489.495n 1.8v 1489.505n 1.8v 1499.495n 1.8v 1499.505n 1.8v 1509.495n 1.8v 1509.505n 1.8v 1519.495n 1.8v 1519.505n 1.8v 1529.495n 1.8v 1529.505n 1.8v 1539.495n 1.8v 1539.505n 1.8v 1549.495n 1.8v 1549.505n 0.0v 1559.495n 0.0v 1559.505n 0.0v 1569.495n 0.0v 1569.505n 0.0v 1579.495n 0.0v 1579.505n 0.0v 1589.495n 0.0v 1589.505n 0.0v 1599.495n 0.0v 1599.505n 0.0v 1609.495n 0.0v 1609.505n 0.0v 1619.495n 0.0v 1619.505n 0.0v 1629.495n 0.0v 1629.505n 0.0v 1639.495n 0.0v 1639.505n 1.8v 1649.495n 1.8v 1649.505n 1.8v 1659.495n 1.8v 1659.505n 1.8v 1669.495n 1.8v 1669.505n 1.8v 1679.495n 1.8v 1679.505n 1.8v 1689.495n 1.8v 1689.505n 1.8v 1699.495n 1.8v 1699.505n 1.8v 1709.495n 1.8v 1709.505n 1.8v 1719.495n 1.8v 1719.505n 0.0v 1729.495n 0.0v 1729.505n 0.0v 1739.495n 0.0v 1739.505n 0.0v 1749.495n 0.0v 1749.505n 0.0v 1759.495n 0.0v 1759.505n 0.0v 1769.495n 0.0v 1769.505n 1.8v 1779.495n 1.8v 1779.505n 1.8v 1789.495n 1.8v 1789.505n 0.0v 1799.495n 0.0v 1799.505n 1.8v 1809.495n 1.8v 1809.505n 1.8v 1819.495n 1.8v 1819.505n 1.8v 1829.495n 1.8v 1829.505n 1.8v 1839.495n 1.8v 1839.505n 1.8v 1849.495n 1.8v 1849.505n 1.8v 1859.495n 1.8v 1859.505n 1.8v 1869.495n 1.8v 1869.505n 1.8v 1879.495n 1.8v 1879.505n 1.8v 1889.495n 1.8v 1889.505n 1.8v 1899.495n 1.8v 1899.505n 0.0v 1909.495n 0.0v 1909.505n 1.8v 1919.495n 1.8v 1919.505n 1.8v 1929.495n 1.8v 1929.505n 0.0v 1939.495n 0.0v 1939.505n 0.0v 1949.495n 0.0v 1949.505n 0.0v 1959.495n 0.0v 1959.505n 0.0v 1969.495n 0.0v 1969.505n 0.0v 1979.495n 0.0v 1979.505n 0.0v 1989.495n 0.0v 1989.505n 0.0v 1999.495n 0.0v 1999.505n 0.0v 2009.495n 0.0v 2009.505n 1.8v 2019.495n 1.8v 2019.505n 1.8v 2029.495n 1.8v 2029.505n 1.8v 2039.495n 1.8v 2039.505n 1.8v 2049.495n 1.8v 2049.505n 1.8v )
* (time, data): [(0, 0), (10, 1), (20, 0), (30, 0), (40, 0), (50, 0), (60, 0), (70, 0), (80, 0), (90, 1), (100, 1), (110, 1), (120, 0), (130, 0), (140, 0), (150, 0), (160, 0), (170, 0), (180, 0), (190, 0), (200, 1), (210, 1), (220, 1), (230, 1), (240, 1), (250, 1), (260, 1), (270, 1), (280, 1), (290, 1), (300, 1), (310, 1), (320, 1), (330, 1), (340, 1), (350, 1), (360, 0), (370, 0), (380, 1), (390, 1), (400, 1), (410, 1), (420, 1), (430, 1), (440, 1), (450, 1), (460, 1), (470, 1), (480, 1), (490, 1), (500, 1), (510, 0), (520, 0), (530, 0), (540, 1), (550, 1), (560, 1), (570, 1), (580, 0), (590, 1), (600, 1), (610, 1), (620, 1), (630, 1), (640, 1), (650, 1), (660, 1), (670, 1), (680, 1), (690, 1), (700, 1), (710, 1), (720, 1), (730, 0), (740, 0), (750, 0), (760, 1), (770, 0), (780, 0), (790, 0), (800, 1), (810, 1), (820, 1), (830, 1), (840, 1), (850, 1), (860, 1), (870, 1), (880, 1), (890, 1), (900, 1), (910, 1), (920, 0), (930, 0), (940, 0), (950, 0), (960, 0), (970, 0), (980, 1), (990, 1), (1000, 1), (1010, 1), (1020, 1), (1030, 1), (1040, 1), (1050, 1), (1060, 1), (1070, 1), (1080, 1), (1090, 1), (1100, 1), (1110, 1), (1120, 0), (1130, 0), (1140, 0), (1150, 0), (1160, 1), (1170, 0), (1180, 0), (1190, 0), (1200, 1), (1210, 1), (1220, 1), (1230, 0), (1240, 1), (1250, 0), (1260, 0), (1270, 0), (1280, 0), (1290, 0), (1300, 0), (1310, 0), (1320, 1), (1330, 0), (1340, 1), (1350, 0), (1360, 0), (1370, 1), (1380, 1), (1390, 1), (1400, 1), (1410, 1), (1420, 1), (1430, 1), (1440, 0), (1450, 0), (1460, 1), (1470, 1), (1480, 1), (1490, 1), (1500, 1), (1510, 1), (1520, 1), (1530, 1), (1540, 1), (1550, 1), (1560, 1), (1570, 1), (1580, 1), (1590, 1), (1600, 1), (1610, 1), (1620, 1), (1630, 1), (1640, 1), (1650, 1), (1660, 1), (1670, 1), (1680, 1), (1690, 1), (1700, 1), (1710, 1), (1720, 0), (1730, 0), (1740, 0), (1750, 0), (1760, 0), (1770, 1), (1780, 1), (1790, 0), (1800, 1), (1810, 0), (1820, 0), (1830, 0), (1840, 0), (1850, 0), (1860, 0), (1870, 0), (1880, 1), (1890, 1), (1900, 1), (1910, 0), (1920, 0), (1930, 1), (1940, 1), (1950, 1), (1960, 1), (1970, 1), (1980, 0), (1990, 0), (2000, 0), (2010, 0), (2020, 0), (2030, 0), (2040, 0), (2050, 0)]
Vdin0_20  din0_20  0 PWL (0n 0.0v 9.495n 0.0v 9.505n 1.8v 19.495n 1.8v 19.505n 0.0v 29.495n 0.0v 29.505n 0.0v 39.495n 0.0v 39.505n 0.0v 49.495n 0.0v 49.505n 0.0v 59.495n 0.0v 59.505n 0.0v 69.495n 0.0v 69.505n 0.0v 79.495n 0.0v 79.505n 0.0v 89.495n 0.0v 89.505n 1.8v 99.495n 1.8v 99.505n 1.8v 109.495n 1.8v 109.505n 1.8v 119.495n 1.8v 119.505n 0.0v 129.495n 0.0v 129.505n 0.0v 139.495n 0.0v 139.505n 0.0v 149.495n 0.0v 149.505n 0.0v 159.495n 0.0v 159.505n 0.0v 169.495n 0.0v 169.505n 0.0v 179.495n 0.0v 179.505n 0.0v 189.495n 0.0v 189.505n 0.0v 199.495n 0.0v 199.505n 1.8v 209.495n 1.8v 209.505n 1.8v 219.495n 1.8v 219.505n 1.8v 229.495n 1.8v 229.505n 1.8v 239.495n 1.8v 239.505n 1.8v 249.495n 1.8v 249.505n 1.8v 259.495n 1.8v 259.505n 1.8v 269.495n 1.8v 269.505n 1.8v 279.495n 1.8v 279.505n 1.8v 289.495n 1.8v 289.505n 1.8v 299.495n 1.8v 299.505n 1.8v 309.495n 1.8v 309.505n 1.8v 319.495n 1.8v 319.505n 1.8v 329.495n 1.8v 329.505n 1.8v 339.495n 1.8v 339.505n 1.8v 349.495n 1.8v 349.505n 1.8v 359.495n 1.8v 359.505n 0.0v 369.495n 0.0v 369.505n 0.0v 379.495n 0.0v 379.505n 1.8v 389.495n 1.8v 389.505n 1.8v 399.495n 1.8v 399.505n 1.8v 409.495n 1.8v 409.505n 1.8v 419.495n 1.8v 419.505n 1.8v 429.495n 1.8v 429.505n 1.8v 439.495n 1.8v 439.505n 1.8v 449.495n 1.8v 449.505n 1.8v 459.495n 1.8v 459.505n 1.8v 469.495n 1.8v 469.505n 1.8v 479.495n 1.8v 479.505n 1.8v 489.495n 1.8v 489.505n 1.8v 499.495n 1.8v 499.505n 1.8v 509.495n 1.8v 509.505n 0.0v 519.495n 0.0v 519.505n 0.0v 529.495n 0.0v 529.505n 0.0v 539.495n 0.0v 539.505n 1.8v 549.495n 1.8v 549.505n 1.8v 559.495n 1.8v 559.505n 1.8v 569.495n 1.8v 569.505n 1.8v 579.495n 1.8v 579.505n 0.0v 589.495n 0.0v 589.505n 1.8v 599.495n 1.8v 599.505n 1.8v 609.495n 1.8v 609.505n 1.8v 619.495n 1.8v 619.505n 1.8v 629.495n 1.8v 629.505n 1.8v 639.495n 1.8v 639.505n 1.8v 649.495n 1.8v 649.505n 1.8v 659.495n 1.8v 659.505n 1.8v 669.495n 1.8v 669.505n 1.8v 679.495n 1.8v 679.505n 1.8v 689.495n 1.8v 689.505n 1.8v 699.495n 1.8v 699.505n 1.8v 709.495n 1.8v 709.505n 1.8v 719.495n 1.8v 719.505n 1.8v 729.495n 1.8v 729.505n 0.0v 739.495n 0.0v 739.505n 0.0v 749.495n 0.0v 749.505n 0.0v 759.495n 0.0v 759.505n 1.8v 769.495n 1.8v 769.505n 0.0v 779.495n 0.0v 779.505n 0.0v 789.495n 0.0v 789.505n 0.0v 799.495n 0.0v 799.505n 1.8v 809.495n 1.8v 809.505n 1.8v 819.495n 1.8v 819.505n 1.8v 829.495n 1.8v 829.505n 1.8v 839.495n 1.8v 839.505n 1.8v 849.495n 1.8v 849.505n 1.8v 859.495n 1.8v 859.505n 1.8v 869.495n 1.8v 869.505n 1.8v 879.495n 1.8v 879.505n 1.8v 889.495n 1.8v 889.505n 1.8v 899.495n 1.8v 899.505n 1.8v 909.495n 1.8v 909.505n 1.8v 919.495n 1.8v 919.505n 0.0v 929.495n 0.0v 929.505n 0.0v 939.495n 0.0v 939.505n 0.0v 949.495n 0.0v 949.505n 0.0v 959.495n 0.0v 959.505n 0.0v 969.495n 0.0v 969.505n 0.0v 979.495n 0.0v 979.505n 1.8v 989.495n 1.8v 989.505n 1.8v 999.495n 1.8v 999.505n 1.8v 1009.495n 1.8v 1009.505n 1.8v 1019.495n 1.8v 1019.505n 1.8v 1029.495n 1.8v 1029.505n 1.8v 1039.495n 1.8v 1039.505n 1.8v 1049.495n 1.8v 1049.505n 1.8v 1059.495n 1.8v 1059.505n 1.8v 1069.495n 1.8v 1069.505n 1.8v 1079.495n 1.8v 1079.505n 1.8v 1089.495n 1.8v 1089.505n 1.8v 1099.495n 1.8v 1099.505n 1.8v 1109.495n 1.8v 1109.505n 1.8v 1119.495n 1.8v 1119.505n 0.0v 1129.495n 0.0v 1129.505n 0.0v 1139.495n 0.0v 1139.505n 0.0v 1149.495n 0.0v 1149.505n 0.0v 1159.495n 0.0v 1159.505n 1.8v 1169.495n 1.8v 1169.505n 0.0v 1179.495n 0.0v 1179.505n 0.0v 1189.495n 0.0v 1189.505n 0.0v 1199.495n 0.0v 1199.505n 1.8v 1209.495n 1.8v 1209.505n 1.8v 1219.495n 1.8v 1219.505n 1.8v 1229.495n 1.8v 1229.505n 0.0v 1239.495n 0.0v 1239.505n 1.8v 1249.495n 1.8v 1249.505n 0.0v 1259.495n 0.0v 1259.505n 0.0v 1269.495n 0.0v 1269.505n 0.0v 1279.495n 0.0v 1279.505n 0.0v 1289.495n 0.0v 1289.505n 0.0v 1299.495n 0.0v 1299.505n 0.0v 1309.495n 0.0v 1309.505n 0.0v 1319.495n 0.0v 1319.505n 1.8v 1329.495n 1.8v 1329.505n 0.0v 1339.495n 0.0v 1339.505n 1.8v 1349.495n 1.8v 1349.505n 0.0v 1359.495n 0.0v 1359.505n 0.0v 1369.495n 0.0v 1369.505n 1.8v 1379.495n 1.8v 1379.505n 1.8v 1389.495n 1.8v 1389.505n 1.8v 1399.495n 1.8v 1399.505n 1.8v 1409.495n 1.8v 1409.505n 1.8v 1419.495n 1.8v 1419.505n 1.8v 1429.495n 1.8v 1429.505n 1.8v 1439.495n 1.8v 1439.505n 0.0v 1449.495n 0.0v 1449.505n 0.0v 1459.495n 0.0v 1459.505n 1.8v 1469.495n 1.8v 1469.505n 1.8v 1479.495n 1.8v 1479.505n 1.8v 1489.495n 1.8v 1489.505n 1.8v 1499.495n 1.8v 1499.505n 1.8v 1509.495n 1.8v 1509.505n 1.8v 1519.495n 1.8v 1519.505n 1.8v 1529.495n 1.8v 1529.505n 1.8v 1539.495n 1.8v 1539.505n 1.8v 1549.495n 1.8v 1549.505n 1.8v 1559.495n 1.8v 1559.505n 1.8v 1569.495n 1.8v 1569.505n 1.8v 1579.495n 1.8v 1579.505n 1.8v 1589.495n 1.8v 1589.505n 1.8v 1599.495n 1.8v 1599.505n 1.8v 1609.495n 1.8v 1609.505n 1.8v 1619.495n 1.8v 1619.505n 1.8v 1629.495n 1.8v 1629.505n 1.8v 1639.495n 1.8v 1639.505n 1.8v 1649.495n 1.8v 1649.505n 1.8v 1659.495n 1.8v 1659.505n 1.8v 1669.495n 1.8v 1669.505n 1.8v 1679.495n 1.8v 1679.505n 1.8v 1689.495n 1.8v 1689.505n 1.8v 1699.495n 1.8v 1699.505n 1.8v 1709.495n 1.8v 1709.505n 1.8v 1719.495n 1.8v 1719.505n 0.0v 1729.495n 0.0v 1729.505n 0.0v 1739.495n 0.0v 1739.505n 0.0v 1749.495n 0.0v 1749.505n 0.0v 1759.495n 0.0v 1759.505n 0.0v 1769.495n 0.0v 1769.505n 1.8v 1779.495n 1.8v 1779.505n 1.8v 1789.495n 1.8v 1789.505n 0.0v 1799.495n 0.0v 1799.505n 1.8v 1809.495n 1.8v 1809.505n 0.0v 1819.495n 0.0v 1819.505n 0.0v 1829.495n 0.0v 1829.505n 0.0v 1839.495n 0.0v 1839.505n 0.0v 1849.495n 0.0v 1849.505n 0.0v 1859.495n 0.0v 1859.505n 0.0v 1869.495n 0.0v 1869.505n 0.0v 1879.495n 0.0v 1879.505n 1.8v 1889.495n 1.8v 1889.505n 1.8v 1899.495n 1.8v 1899.505n 1.8v 1909.495n 1.8v 1909.505n 0.0v 1919.495n 0.0v 1919.505n 0.0v 1929.495n 0.0v 1929.505n 1.8v 1939.495n 1.8v 1939.505n 1.8v 1949.495n 1.8v 1949.505n 1.8v 1959.495n 1.8v 1959.505n 1.8v 1969.495n 1.8v 1969.505n 1.8v 1979.495n 1.8v 1979.505n 0.0v 1989.495n 0.0v 1989.505n 0.0v 1999.495n 0.0v 1999.505n 0.0v 2009.495n 0.0v 2009.505n 0.0v 2019.495n 0.0v 2019.505n 0.0v 2029.495n 0.0v 2029.505n 0.0v 2039.495n 0.0v 2039.505n 0.0v 2049.495n 0.0v 2049.505n 0.0v )
* (time, data): [(0, 0), (10, 0), (20, 1), (30, 0), (40, 0), (50, 0), (60, 0), (70, 0), (80, 0), (90, 1), (100, 1), (110, 1), (120, 0), (130, 0), (140, 0), (150, 0), (160, 0), (170, 0), (180, 0), (190, 0), (200, 0), (210, 0), (220, 1), (230, 1), (240, 1), (250, 0), (260, 0), (270, 0), (280, 0), (290, 0), (300, 0), (310, 0), (320, 0), (330, 0), (340, 0), (350, 0), (360, 1), (370, 1), (380, 1), (390, 1), (400, 1), (410, 0), (420, 1), (430, 1), (440, 1), (450, 1), (460, 1), (470, 1), (480, 1), (490, 0), (500, 0), (510, 1), (520, 1), (530, 1), (540, 0), (550, 0), (560, 0), (570, 0), (580, 1), (590, 0), (600, 0), (610, 0), (620, 0), (630, 0), (640, 0), (650, 0), (660, 0), (670, 0), (680, 0), (690, 0), (700, 0), (710, 0), (720, 0), (730, 1), (740, 0), (750, 0), (760, 1), (770, 0), (780, 1), (790, 1), (800, 1), (810, 1), (820, 1), (830, 1), (840, 1), (850, 1), (860, 1), (870, 0), (880, 0), (890, 0), (900, 0), (910, 0), (920, 0), (930, 0), (940, 0), (950, 0), (960, 0), (970, 0), (980, 0), (990, 0), (1000, 1), (1010, 1), (1020, 1), (1030, 1), (1040, 1), (1050, 1), (1060, 1), (1070, 1), (1080, 1), (1090, 1), (1100, 1), (1110, 1), (1120, 1), (1130, 1), (1140, 1), (1150, 1), (1160, 1), (1170, 0), (1180, 0), (1190, 0), (1200, 0), (1210, 0), (1220, 0), (1230, 0), (1240, 1), (1250, 0), (1260, 0), (1270, 1), (1280, 1), (1290, 1), (1300, 1), (1310, 1), (1320, 1), (1330, 0), (1340, 1), (1350, 0), (1360, 1), (1370, 0), (1380, 0), (1390, 0), (1400, 0), (1410, 0), (1420, 0), (1430, 0), (1440, 1), (1450, 1), (1460, 0), (1470, 1), (1480, 1), (1490, 1), (1500, 1), (1510, 1), (1520, 1), (1530, 1), (1540, 1), (1550, 0), (1560, 1), (1570, 1), (1580, 1), (1590, 1), (1600, 1), (1610, 1), (1620, 1), (1630, 1), (1640, 0), (1650, 0), (1660, 0), (1670, 0), (1680, 0), (1690, 0), (1700, 0), (1710, 0), (1720, 0), (1730, 0), (1740, 0), (1750, 0), (1760, 0), (1770, 0), (1780, 0), (1790, 0), (1800, 0), (1810, 0), (1820, 0), (1830, 0), (1840, 0), (1850, 0), (1860, 0), (1870, 0), (1880, 1), (1890, 1), (1900, 1), (1910, 1), (1920, 1), (1930, 1), (1940, 1), (1950, 1), (1960, 1), (1970, 1), (1980, 1), (1990, 1), (2000, 1), (2010, 0), (2020, 0), (2030, 0), (2040, 0), (2050, 0)]
Vdin0_21  din0_21  0 PWL (0n 0.0v 9.495n 0.0v 9.505n 0.0v 19.495n 0.0v 19.505n 1.8v 29.495n 1.8v 29.505n 0.0v 39.495n 0.0v 39.505n 0.0v 49.495n 0.0v 49.505n 0.0v 59.495n 0.0v 59.505n 0.0v 69.495n 0.0v 69.505n 0.0v 79.495n 0.0v 79.505n 0.0v 89.495n 0.0v 89.505n 1.8v 99.495n 1.8v 99.505n 1.8v 109.495n 1.8v 109.505n 1.8v 119.495n 1.8v 119.505n 0.0v 129.495n 0.0v 129.505n 0.0v 139.495n 0.0v 139.505n 0.0v 149.495n 0.0v 149.505n 0.0v 159.495n 0.0v 159.505n 0.0v 169.495n 0.0v 169.505n 0.0v 179.495n 0.0v 179.505n 0.0v 189.495n 0.0v 189.505n 0.0v 199.495n 0.0v 199.505n 0.0v 209.495n 0.0v 209.505n 0.0v 219.495n 0.0v 219.505n 1.8v 229.495n 1.8v 229.505n 1.8v 239.495n 1.8v 239.505n 1.8v 249.495n 1.8v 249.505n 0.0v 259.495n 0.0v 259.505n 0.0v 269.495n 0.0v 269.505n 0.0v 279.495n 0.0v 279.505n 0.0v 289.495n 0.0v 289.505n 0.0v 299.495n 0.0v 299.505n 0.0v 309.495n 0.0v 309.505n 0.0v 319.495n 0.0v 319.505n 0.0v 329.495n 0.0v 329.505n 0.0v 339.495n 0.0v 339.505n 0.0v 349.495n 0.0v 349.505n 0.0v 359.495n 0.0v 359.505n 1.8v 369.495n 1.8v 369.505n 1.8v 379.495n 1.8v 379.505n 1.8v 389.495n 1.8v 389.505n 1.8v 399.495n 1.8v 399.505n 1.8v 409.495n 1.8v 409.505n 0.0v 419.495n 0.0v 419.505n 1.8v 429.495n 1.8v 429.505n 1.8v 439.495n 1.8v 439.505n 1.8v 449.495n 1.8v 449.505n 1.8v 459.495n 1.8v 459.505n 1.8v 469.495n 1.8v 469.505n 1.8v 479.495n 1.8v 479.505n 1.8v 489.495n 1.8v 489.505n 0.0v 499.495n 0.0v 499.505n 0.0v 509.495n 0.0v 509.505n 1.8v 519.495n 1.8v 519.505n 1.8v 529.495n 1.8v 529.505n 1.8v 539.495n 1.8v 539.505n 0.0v 549.495n 0.0v 549.505n 0.0v 559.495n 0.0v 559.505n 0.0v 569.495n 0.0v 569.505n 0.0v 579.495n 0.0v 579.505n 1.8v 589.495n 1.8v 589.505n 0.0v 599.495n 0.0v 599.505n 0.0v 609.495n 0.0v 609.505n 0.0v 619.495n 0.0v 619.505n 0.0v 629.495n 0.0v 629.505n 0.0v 639.495n 0.0v 639.505n 0.0v 649.495n 0.0v 649.505n 0.0v 659.495n 0.0v 659.505n 0.0v 669.495n 0.0v 669.505n 0.0v 679.495n 0.0v 679.505n 0.0v 689.495n 0.0v 689.505n 0.0v 699.495n 0.0v 699.505n 0.0v 709.495n 0.0v 709.505n 0.0v 719.495n 0.0v 719.505n 0.0v 729.495n 0.0v 729.505n 1.8v 739.495n 1.8v 739.505n 0.0v 749.495n 0.0v 749.505n 0.0v 759.495n 0.0v 759.505n 1.8v 769.495n 1.8v 769.505n 0.0v 779.495n 0.0v 779.505n 1.8v 789.495n 1.8v 789.505n 1.8v 799.495n 1.8v 799.505n 1.8v 809.495n 1.8v 809.505n 1.8v 819.495n 1.8v 819.505n 1.8v 829.495n 1.8v 829.505n 1.8v 839.495n 1.8v 839.505n 1.8v 849.495n 1.8v 849.505n 1.8v 859.495n 1.8v 859.505n 1.8v 869.495n 1.8v 869.505n 0.0v 879.495n 0.0v 879.505n 0.0v 889.495n 0.0v 889.505n 0.0v 899.495n 0.0v 899.505n 0.0v 909.495n 0.0v 909.505n 0.0v 919.495n 0.0v 919.505n 0.0v 929.495n 0.0v 929.505n 0.0v 939.495n 0.0v 939.505n 0.0v 949.495n 0.0v 949.505n 0.0v 959.495n 0.0v 959.505n 0.0v 969.495n 0.0v 969.505n 0.0v 979.495n 0.0v 979.505n 0.0v 989.495n 0.0v 989.505n 0.0v 999.495n 0.0v 999.505n 1.8v 1009.495n 1.8v 1009.505n 1.8v 1019.495n 1.8v 1019.505n 1.8v 1029.495n 1.8v 1029.505n 1.8v 1039.495n 1.8v 1039.505n 1.8v 1049.495n 1.8v 1049.505n 1.8v 1059.495n 1.8v 1059.505n 1.8v 1069.495n 1.8v 1069.505n 1.8v 1079.495n 1.8v 1079.505n 1.8v 1089.495n 1.8v 1089.505n 1.8v 1099.495n 1.8v 1099.505n 1.8v 1109.495n 1.8v 1109.505n 1.8v 1119.495n 1.8v 1119.505n 1.8v 1129.495n 1.8v 1129.505n 1.8v 1139.495n 1.8v 1139.505n 1.8v 1149.495n 1.8v 1149.505n 1.8v 1159.495n 1.8v 1159.505n 1.8v 1169.495n 1.8v 1169.505n 0.0v 1179.495n 0.0v 1179.505n 0.0v 1189.495n 0.0v 1189.505n 0.0v 1199.495n 0.0v 1199.505n 0.0v 1209.495n 0.0v 1209.505n 0.0v 1219.495n 0.0v 1219.505n 0.0v 1229.495n 0.0v 1229.505n 0.0v 1239.495n 0.0v 1239.505n 1.8v 1249.495n 1.8v 1249.505n 0.0v 1259.495n 0.0v 1259.505n 0.0v 1269.495n 0.0v 1269.505n 1.8v 1279.495n 1.8v 1279.505n 1.8v 1289.495n 1.8v 1289.505n 1.8v 1299.495n 1.8v 1299.505n 1.8v 1309.495n 1.8v 1309.505n 1.8v 1319.495n 1.8v 1319.505n 1.8v 1329.495n 1.8v 1329.505n 0.0v 1339.495n 0.0v 1339.505n 1.8v 1349.495n 1.8v 1349.505n 0.0v 1359.495n 0.0v 1359.505n 1.8v 1369.495n 1.8v 1369.505n 0.0v 1379.495n 0.0v 1379.505n 0.0v 1389.495n 0.0v 1389.505n 0.0v 1399.495n 0.0v 1399.505n 0.0v 1409.495n 0.0v 1409.505n 0.0v 1419.495n 0.0v 1419.505n 0.0v 1429.495n 0.0v 1429.505n 0.0v 1439.495n 0.0v 1439.505n 1.8v 1449.495n 1.8v 1449.505n 1.8v 1459.495n 1.8v 1459.505n 0.0v 1469.495n 0.0v 1469.505n 1.8v 1479.495n 1.8v 1479.505n 1.8v 1489.495n 1.8v 1489.505n 1.8v 1499.495n 1.8v 1499.505n 1.8v 1509.495n 1.8v 1509.505n 1.8v 1519.495n 1.8v 1519.505n 1.8v 1529.495n 1.8v 1529.505n 1.8v 1539.495n 1.8v 1539.505n 1.8v 1549.495n 1.8v 1549.505n 0.0v 1559.495n 0.0v 1559.505n 1.8v 1569.495n 1.8v 1569.505n 1.8v 1579.495n 1.8v 1579.505n 1.8v 1589.495n 1.8v 1589.505n 1.8v 1599.495n 1.8v 1599.505n 1.8v 1609.495n 1.8v 1609.505n 1.8v 1619.495n 1.8v 1619.505n 1.8v 1629.495n 1.8v 1629.505n 1.8v 1639.495n 1.8v 1639.505n 0.0v 1649.495n 0.0v 1649.505n 0.0v 1659.495n 0.0v 1659.505n 0.0v 1669.495n 0.0v 1669.505n 0.0v 1679.495n 0.0v 1679.505n 0.0v 1689.495n 0.0v 1689.505n 0.0v 1699.495n 0.0v 1699.505n 0.0v 1709.495n 0.0v 1709.505n 0.0v 1719.495n 0.0v 1719.505n 0.0v 1729.495n 0.0v 1729.505n 0.0v 1739.495n 0.0v 1739.505n 0.0v 1749.495n 0.0v 1749.505n 0.0v 1759.495n 0.0v 1759.505n 0.0v 1769.495n 0.0v 1769.505n 0.0v 1779.495n 0.0v 1779.505n 0.0v 1789.495n 0.0v 1789.505n 0.0v 1799.495n 0.0v 1799.505n 0.0v 1809.495n 0.0v 1809.505n 0.0v 1819.495n 0.0v 1819.505n 0.0v 1829.495n 0.0v 1829.505n 0.0v 1839.495n 0.0v 1839.505n 0.0v 1849.495n 0.0v 1849.505n 0.0v 1859.495n 0.0v 1859.505n 0.0v 1869.495n 0.0v 1869.505n 0.0v 1879.495n 0.0v 1879.505n 1.8v 1889.495n 1.8v 1889.505n 1.8v 1899.495n 1.8v 1899.505n 1.8v 1909.495n 1.8v 1909.505n 1.8v 1919.495n 1.8v 1919.505n 1.8v 1929.495n 1.8v 1929.505n 1.8v 1939.495n 1.8v 1939.505n 1.8v 1949.495n 1.8v 1949.505n 1.8v 1959.495n 1.8v 1959.505n 1.8v 1969.495n 1.8v 1969.505n 1.8v 1979.495n 1.8v 1979.505n 1.8v 1989.495n 1.8v 1989.505n 1.8v 1999.495n 1.8v 1999.505n 1.8v 2009.495n 1.8v 2009.505n 0.0v 2019.495n 0.0v 2019.505n 0.0v 2029.495n 0.0v 2029.505n 0.0v 2039.495n 0.0v 2039.505n 0.0v 2049.495n 0.0v 2049.505n 0.0v )
* (time, data): [(0, 0), (10, 1), (20, 1), (30, 1), (40, 1), (50, 1), (60, 1), (70, 1), (80, 1), (90, 1), (100, 1), (110, 1), (120, 0), (130, 0), (140, 0), (150, 0), (160, 0), (170, 0), (180, 0), (190, 0), (200, 0), (210, 0), (220, 0), (230, 0), (240, 0), (250, 0), (260, 0), (270, 0), (280, 0), (290, 0), (300, 0), (310, 0), (320, 0), (330, 0), (340, 0), (350, 0), (360, 1), (370, 1), (380, 0), (390, 0), (400, 0), (410, 0), (420, 1), (430, 1), (440, 1), (450, 1), (460, 1), (470, 1), (480, 1), (490, 1), (500, 1), (510, 1), (520, 1), (530, 0), (540, 0), (550, 0), (560, 0), (570, 0), (580, 0), (590, 1), (600, 1), (610, 1), (620, 1), (630, 1), (640, 1), (650, 1), (660, 0), (670, 0), (680, 0), (690, 0), (700, 0), (710, 0), (720, 0), (730, 1), (740, 0), (750, 0), (760, 1), (770, 1), (780, 0), (790, 0), (800, 0), (810, 0), (820, 0), (830, 0), (840, 0), (850, 0), (860, 0), (870, 0), (880, 0), (890, 0), (900, 0), (910, 0), (920, 0), (930, 0), (940, 0), (950, 0), (960, 0), (970, 0), (980, 1), (990, 1), (1000, 0), (1010, 0), (1020, 1), (1030, 1), (1040, 1), (1050, 1), (1060, 1), (1070, 1), (1080, 1), (1090, 1), (1100, 1), (1110, 1), (1120, 1), (1130, 1), (1140, 1), (1150, 1), (1160, 0), (1170, 0), (1180, 0), (1190, 0), (1200, 0), (1210, 0), (1220, 0), (1230, 0), (1240, 0), (1250, 1), (1260, 1), (1270, 1), (1280, 1), (1290, 1), (1300, 1), (1310, 1), (1320, 0), (1330, 0), (1340, 0), (1350, 1), (1360, 0), (1370, 0), (1380, 0), (1390, 0), (1400, 0), (1410, 0), (1420, 0), (1430, 0), (1440, 0), (1450, 0), (1460, 1), (1470, 0), (1480, 0), (1490, 0), (1500, 0), (1510, 0), (1520, 0), (1530, 0), (1540, 0), (1550, 1), (1560, 0), (1570, 0), (1580, 0), (1590, 1), (1600, 1), (1610, 1), (1620, 1), (1630, 1), (1640, 1), (1650, 1), (1660, 1), (1670, 1), (1680, 1), (1690, 1), (1700, 1), (1710, 1), (1720, 1), (1730, 1), (1740, 1), (1750, 1), (1760, 1), (1770, 1), (1780, 1), (1790, 0), (1800, 0), (1810, 1), (1820, 1), (1830, 1), (1840, 1), (1850, 1), (1860, 1), (1870, 1), (1880, 1), (1890, 1), (1900, 0), (1910, 0), (1920, 0), (1930, 0), (1940, 0), (1950, 0), (1960, 0), (1970, 0), (1980, 1), (1990, 1), (2000, 1), (2010, 1), (2020, 1), (2030, 1), (2040, 1), (2050, 1)]
Vdin0_22  din0_22  0 PWL (0n 0.0v 9.495n 0.0v 9.505n 1.8v 19.495n 1.8v 19.505n 1.8v 29.495n 1.8v 29.505n 1.8v 39.495n 1.8v 39.505n 1.8v 49.495n 1.8v 49.505n 1.8v 59.495n 1.8v 59.505n 1.8v 69.495n 1.8v 69.505n 1.8v 79.495n 1.8v 79.505n 1.8v 89.495n 1.8v 89.505n 1.8v 99.495n 1.8v 99.505n 1.8v 109.495n 1.8v 109.505n 1.8v 119.495n 1.8v 119.505n 0.0v 129.495n 0.0v 129.505n 0.0v 139.495n 0.0v 139.505n 0.0v 149.495n 0.0v 149.505n 0.0v 159.495n 0.0v 159.505n 0.0v 169.495n 0.0v 169.505n 0.0v 179.495n 0.0v 179.505n 0.0v 189.495n 0.0v 189.505n 0.0v 199.495n 0.0v 199.505n 0.0v 209.495n 0.0v 209.505n 0.0v 219.495n 0.0v 219.505n 0.0v 229.495n 0.0v 229.505n 0.0v 239.495n 0.0v 239.505n 0.0v 249.495n 0.0v 249.505n 0.0v 259.495n 0.0v 259.505n 0.0v 269.495n 0.0v 269.505n 0.0v 279.495n 0.0v 279.505n 0.0v 289.495n 0.0v 289.505n 0.0v 299.495n 0.0v 299.505n 0.0v 309.495n 0.0v 309.505n 0.0v 319.495n 0.0v 319.505n 0.0v 329.495n 0.0v 329.505n 0.0v 339.495n 0.0v 339.505n 0.0v 349.495n 0.0v 349.505n 0.0v 359.495n 0.0v 359.505n 1.8v 369.495n 1.8v 369.505n 1.8v 379.495n 1.8v 379.505n 0.0v 389.495n 0.0v 389.505n 0.0v 399.495n 0.0v 399.505n 0.0v 409.495n 0.0v 409.505n 0.0v 419.495n 0.0v 419.505n 1.8v 429.495n 1.8v 429.505n 1.8v 439.495n 1.8v 439.505n 1.8v 449.495n 1.8v 449.505n 1.8v 459.495n 1.8v 459.505n 1.8v 469.495n 1.8v 469.505n 1.8v 479.495n 1.8v 479.505n 1.8v 489.495n 1.8v 489.505n 1.8v 499.495n 1.8v 499.505n 1.8v 509.495n 1.8v 509.505n 1.8v 519.495n 1.8v 519.505n 1.8v 529.495n 1.8v 529.505n 0.0v 539.495n 0.0v 539.505n 0.0v 549.495n 0.0v 549.505n 0.0v 559.495n 0.0v 559.505n 0.0v 569.495n 0.0v 569.505n 0.0v 579.495n 0.0v 579.505n 0.0v 589.495n 0.0v 589.505n 1.8v 599.495n 1.8v 599.505n 1.8v 609.495n 1.8v 609.505n 1.8v 619.495n 1.8v 619.505n 1.8v 629.495n 1.8v 629.505n 1.8v 639.495n 1.8v 639.505n 1.8v 649.495n 1.8v 649.505n 1.8v 659.495n 1.8v 659.505n 0.0v 669.495n 0.0v 669.505n 0.0v 679.495n 0.0v 679.505n 0.0v 689.495n 0.0v 689.505n 0.0v 699.495n 0.0v 699.505n 0.0v 709.495n 0.0v 709.505n 0.0v 719.495n 0.0v 719.505n 0.0v 729.495n 0.0v 729.505n 1.8v 739.495n 1.8v 739.505n 0.0v 749.495n 0.0v 749.505n 0.0v 759.495n 0.0v 759.505n 1.8v 769.495n 1.8v 769.505n 1.8v 779.495n 1.8v 779.505n 0.0v 789.495n 0.0v 789.505n 0.0v 799.495n 0.0v 799.505n 0.0v 809.495n 0.0v 809.505n 0.0v 819.495n 0.0v 819.505n 0.0v 829.495n 0.0v 829.505n 0.0v 839.495n 0.0v 839.505n 0.0v 849.495n 0.0v 849.505n 0.0v 859.495n 0.0v 859.505n 0.0v 869.495n 0.0v 869.505n 0.0v 879.495n 0.0v 879.505n 0.0v 889.495n 0.0v 889.505n 0.0v 899.495n 0.0v 899.505n 0.0v 909.495n 0.0v 909.505n 0.0v 919.495n 0.0v 919.505n 0.0v 929.495n 0.0v 929.505n 0.0v 939.495n 0.0v 939.505n 0.0v 949.495n 0.0v 949.505n 0.0v 959.495n 0.0v 959.505n 0.0v 969.495n 0.0v 969.505n 0.0v 979.495n 0.0v 979.505n 1.8v 989.495n 1.8v 989.505n 1.8v 999.495n 1.8v 999.505n 0.0v 1009.495n 0.0v 1009.505n 0.0v 1019.495n 0.0v 1019.505n 1.8v 1029.495n 1.8v 1029.505n 1.8v 1039.495n 1.8v 1039.505n 1.8v 1049.495n 1.8v 1049.505n 1.8v 1059.495n 1.8v 1059.505n 1.8v 1069.495n 1.8v 1069.505n 1.8v 1079.495n 1.8v 1079.505n 1.8v 1089.495n 1.8v 1089.505n 1.8v 1099.495n 1.8v 1099.505n 1.8v 1109.495n 1.8v 1109.505n 1.8v 1119.495n 1.8v 1119.505n 1.8v 1129.495n 1.8v 1129.505n 1.8v 1139.495n 1.8v 1139.505n 1.8v 1149.495n 1.8v 1149.505n 1.8v 1159.495n 1.8v 1159.505n 0.0v 1169.495n 0.0v 1169.505n 0.0v 1179.495n 0.0v 1179.505n 0.0v 1189.495n 0.0v 1189.505n 0.0v 1199.495n 0.0v 1199.505n 0.0v 1209.495n 0.0v 1209.505n 0.0v 1219.495n 0.0v 1219.505n 0.0v 1229.495n 0.0v 1229.505n 0.0v 1239.495n 0.0v 1239.505n 0.0v 1249.495n 0.0v 1249.505n 1.8v 1259.495n 1.8v 1259.505n 1.8v 1269.495n 1.8v 1269.505n 1.8v 1279.495n 1.8v 1279.505n 1.8v 1289.495n 1.8v 1289.505n 1.8v 1299.495n 1.8v 1299.505n 1.8v 1309.495n 1.8v 1309.505n 1.8v 1319.495n 1.8v 1319.505n 0.0v 1329.495n 0.0v 1329.505n 0.0v 1339.495n 0.0v 1339.505n 0.0v 1349.495n 0.0v 1349.505n 1.8v 1359.495n 1.8v 1359.505n 0.0v 1369.495n 0.0v 1369.505n 0.0v 1379.495n 0.0v 1379.505n 0.0v 1389.495n 0.0v 1389.505n 0.0v 1399.495n 0.0v 1399.505n 0.0v 1409.495n 0.0v 1409.505n 0.0v 1419.495n 0.0v 1419.505n 0.0v 1429.495n 0.0v 1429.505n 0.0v 1439.495n 0.0v 1439.505n 0.0v 1449.495n 0.0v 1449.505n 0.0v 1459.495n 0.0v 1459.505n 1.8v 1469.495n 1.8v 1469.505n 0.0v 1479.495n 0.0v 1479.505n 0.0v 1489.495n 0.0v 1489.505n 0.0v 1499.495n 0.0v 1499.505n 0.0v 1509.495n 0.0v 1509.505n 0.0v 1519.495n 0.0v 1519.505n 0.0v 1529.495n 0.0v 1529.505n 0.0v 1539.495n 0.0v 1539.505n 0.0v 1549.495n 0.0v 1549.505n 1.8v 1559.495n 1.8v 1559.505n 0.0v 1569.495n 0.0v 1569.505n 0.0v 1579.495n 0.0v 1579.505n 0.0v 1589.495n 0.0v 1589.505n 1.8v 1599.495n 1.8v 1599.505n 1.8v 1609.495n 1.8v 1609.505n 1.8v 1619.495n 1.8v 1619.505n 1.8v 1629.495n 1.8v 1629.505n 1.8v 1639.495n 1.8v 1639.505n 1.8v 1649.495n 1.8v 1649.505n 1.8v 1659.495n 1.8v 1659.505n 1.8v 1669.495n 1.8v 1669.505n 1.8v 1679.495n 1.8v 1679.505n 1.8v 1689.495n 1.8v 1689.505n 1.8v 1699.495n 1.8v 1699.505n 1.8v 1709.495n 1.8v 1709.505n 1.8v 1719.495n 1.8v 1719.505n 1.8v 1729.495n 1.8v 1729.505n 1.8v 1739.495n 1.8v 1739.505n 1.8v 1749.495n 1.8v 1749.505n 1.8v 1759.495n 1.8v 1759.505n 1.8v 1769.495n 1.8v 1769.505n 1.8v 1779.495n 1.8v 1779.505n 1.8v 1789.495n 1.8v 1789.505n 0.0v 1799.495n 0.0v 1799.505n 0.0v 1809.495n 0.0v 1809.505n 1.8v 1819.495n 1.8v 1819.505n 1.8v 1829.495n 1.8v 1829.505n 1.8v 1839.495n 1.8v 1839.505n 1.8v 1849.495n 1.8v 1849.505n 1.8v 1859.495n 1.8v 1859.505n 1.8v 1869.495n 1.8v 1869.505n 1.8v 1879.495n 1.8v 1879.505n 1.8v 1889.495n 1.8v 1889.505n 1.8v 1899.495n 1.8v 1899.505n 0.0v 1909.495n 0.0v 1909.505n 0.0v 1919.495n 0.0v 1919.505n 0.0v 1929.495n 0.0v 1929.505n 0.0v 1939.495n 0.0v 1939.505n 0.0v 1949.495n 0.0v 1949.505n 0.0v 1959.495n 0.0v 1959.505n 0.0v 1969.495n 0.0v 1969.505n 0.0v 1979.495n 0.0v 1979.505n 1.8v 1989.495n 1.8v 1989.505n 1.8v 1999.495n 1.8v 1999.505n 1.8v 2009.495n 1.8v 2009.505n 1.8v 2019.495n 1.8v 2019.505n 1.8v 2029.495n 1.8v 2029.505n 1.8v 2039.495n 1.8v 2039.505n 1.8v 2049.495n 1.8v 2049.505n 1.8v )
* (time, data): [(0, 0), (10, 0), (20, 1), (30, 1), (40, 1), (50, 1), (60, 0), (70, 0), (80, 0), (90, 1), (100, 1), (110, 1), (120, 0), (130, 0), (140, 0), (150, 0), (160, 0), (170, 0), (180, 0), (190, 0), (200, 1), (210, 1), (220, 0), (230, 0), (240, 0), (250, 1), (260, 1), (270, 1), (280, 1), (290, 1), (300, 1), (310, 1), (320, 0), (330, 0), (340, 0), (350, 0), (360, 1), (370, 1), (380, 0), (390, 0), (400, 0), (410, 0), (420, 1), (430, 1), (440, 1), (450, 1), (460, 1), (470, 1), (480, 1), (490, 0), (500, 0), (510, 0), (520, 0), (530, 1), (540, 1), (550, 1), (560, 1), (570, 1), (580, 0), (590, 1), (600, 1), (610, 1), (620, 1), (630, 1), (640, 1), (650, 1), (660, 0), (670, 1), (680, 1), (690, 1), (700, 1), (710, 1), (720, 1), (730, 1), (740, 0), (750, 0), (760, 0), (770, 1), (780, 0), (790, 0), (800, 0), (810, 0), (820, 0), (830, 0), (840, 1), (850, 1), (860, 1), (870, 0), (880, 0), (890, 0), (900, 0), (910, 0), (920, 0), (930, 0), (940, 0), (950, 0), (960, 0), (970, 0), (980, 1), (990, 1), (1000, 1), (1010, 1), (1020, 0), (1030, 0), (1040, 0), (1050, 0), (1060, 0), (1070, 0), (1080, 0), (1090, 0), (1100, 0), (1110, 0), (1120, 1), (1130, 1), (1140, 1), (1150, 1), (1160, 1), (1170, 0), (1180, 0), (1190, 0), (1200, 1), (1210, 1), (1220, 1), (1230, 1), (1240, 1), (1250, 1), (1260, 0), (1270, 0), (1280, 0), (1290, 0), (1300, 0), (1310, 0), (1320, 0), (1330, 0), (1340, 1), (1350, 0), (1360, 1), (1370, 0), (1380, 0), (1390, 0), (1400, 0), (1410, 0), (1420, 0), (1430, 0), (1440, 0), (1450, 0), (1460, 0), (1470, 1), (1480, 1), (1490, 1), (1500, 1), (1510, 1), (1520, 1), (1530, 1), (1540, 1), (1550, 0), (1560, 1), (1570, 1), (1580, 1), (1590, 0), (1600, 0), (1610, 0), (1620, 0), (1630, 0), (1640, 1), (1650, 1), (1660, 1), (1670, 1), (1680, 1), (1690, 1), (1700, 1), (1710, 1), (1720, 1), (1730, 1), (1740, 1), (1750, 1), (1760, 1), (1770, 0), (1780, 0), (1790, 0), (1800, 1), (1810, 0), (1820, 0), (1830, 0), (1840, 0), (1850, 0), (1860, 0), (1870, 0), (1880, 0), (1890, 0), (1900, 0), (1910, 1), (1920, 1), (1930, 1), (1940, 1), (1950, 1), (1960, 1), (1970, 1), (1980, 1), (1990, 1), (2000, 1), (2010, 1), (2020, 1), (2030, 1), (2040, 1), (2050, 1)]
Vdin0_23  din0_23  0 PWL (0n 0.0v 9.495n 0.0v 9.505n 0.0v 19.495n 0.0v 19.505n 1.8v 29.495n 1.8v 29.505n 1.8v 39.495n 1.8v 39.505n 1.8v 49.495n 1.8v 49.505n 1.8v 59.495n 1.8v 59.505n 0.0v 69.495n 0.0v 69.505n 0.0v 79.495n 0.0v 79.505n 0.0v 89.495n 0.0v 89.505n 1.8v 99.495n 1.8v 99.505n 1.8v 109.495n 1.8v 109.505n 1.8v 119.495n 1.8v 119.505n 0.0v 129.495n 0.0v 129.505n 0.0v 139.495n 0.0v 139.505n 0.0v 149.495n 0.0v 149.505n 0.0v 159.495n 0.0v 159.505n 0.0v 169.495n 0.0v 169.505n 0.0v 179.495n 0.0v 179.505n 0.0v 189.495n 0.0v 189.505n 0.0v 199.495n 0.0v 199.505n 1.8v 209.495n 1.8v 209.505n 1.8v 219.495n 1.8v 219.505n 0.0v 229.495n 0.0v 229.505n 0.0v 239.495n 0.0v 239.505n 0.0v 249.495n 0.0v 249.505n 1.8v 259.495n 1.8v 259.505n 1.8v 269.495n 1.8v 269.505n 1.8v 279.495n 1.8v 279.505n 1.8v 289.495n 1.8v 289.505n 1.8v 299.495n 1.8v 299.505n 1.8v 309.495n 1.8v 309.505n 1.8v 319.495n 1.8v 319.505n 0.0v 329.495n 0.0v 329.505n 0.0v 339.495n 0.0v 339.505n 0.0v 349.495n 0.0v 349.505n 0.0v 359.495n 0.0v 359.505n 1.8v 369.495n 1.8v 369.505n 1.8v 379.495n 1.8v 379.505n 0.0v 389.495n 0.0v 389.505n 0.0v 399.495n 0.0v 399.505n 0.0v 409.495n 0.0v 409.505n 0.0v 419.495n 0.0v 419.505n 1.8v 429.495n 1.8v 429.505n 1.8v 439.495n 1.8v 439.505n 1.8v 449.495n 1.8v 449.505n 1.8v 459.495n 1.8v 459.505n 1.8v 469.495n 1.8v 469.505n 1.8v 479.495n 1.8v 479.505n 1.8v 489.495n 1.8v 489.505n 0.0v 499.495n 0.0v 499.505n 0.0v 509.495n 0.0v 509.505n 0.0v 519.495n 0.0v 519.505n 0.0v 529.495n 0.0v 529.505n 1.8v 539.495n 1.8v 539.505n 1.8v 549.495n 1.8v 549.505n 1.8v 559.495n 1.8v 559.505n 1.8v 569.495n 1.8v 569.505n 1.8v 579.495n 1.8v 579.505n 0.0v 589.495n 0.0v 589.505n 1.8v 599.495n 1.8v 599.505n 1.8v 609.495n 1.8v 609.505n 1.8v 619.495n 1.8v 619.505n 1.8v 629.495n 1.8v 629.505n 1.8v 639.495n 1.8v 639.505n 1.8v 649.495n 1.8v 649.505n 1.8v 659.495n 1.8v 659.505n 0.0v 669.495n 0.0v 669.505n 1.8v 679.495n 1.8v 679.505n 1.8v 689.495n 1.8v 689.505n 1.8v 699.495n 1.8v 699.505n 1.8v 709.495n 1.8v 709.505n 1.8v 719.495n 1.8v 719.505n 1.8v 729.495n 1.8v 729.505n 1.8v 739.495n 1.8v 739.505n 0.0v 749.495n 0.0v 749.505n 0.0v 759.495n 0.0v 759.505n 0.0v 769.495n 0.0v 769.505n 1.8v 779.495n 1.8v 779.505n 0.0v 789.495n 0.0v 789.505n 0.0v 799.495n 0.0v 799.505n 0.0v 809.495n 0.0v 809.505n 0.0v 819.495n 0.0v 819.505n 0.0v 829.495n 0.0v 829.505n 0.0v 839.495n 0.0v 839.505n 1.8v 849.495n 1.8v 849.505n 1.8v 859.495n 1.8v 859.505n 1.8v 869.495n 1.8v 869.505n 0.0v 879.495n 0.0v 879.505n 0.0v 889.495n 0.0v 889.505n 0.0v 899.495n 0.0v 899.505n 0.0v 909.495n 0.0v 909.505n 0.0v 919.495n 0.0v 919.505n 0.0v 929.495n 0.0v 929.505n 0.0v 939.495n 0.0v 939.505n 0.0v 949.495n 0.0v 949.505n 0.0v 959.495n 0.0v 959.505n 0.0v 969.495n 0.0v 969.505n 0.0v 979.495n 0.0v 979.505n 1.8v 989.495n 1.8v 989.505n 1.8v 999.495n 1.8v 999.505n 1.8v 1009.495n 1.8v 1009.505n 1.8v 1019.495n 1.8v 1019.505n 0.0v 1029.495n 0.0v 1029.505n 0.0v 1039.495n 0.0v 1039.505n 0.0v 1049.495n 0.0v 1049.505n 0.0v 1059.495n 0.0v 1059.505n 0.0v 1069.495n 0.0v 1069.505n 0.0v 1079.495n 0.0v 1079.505n 0.0v 1089.495n 0.0v 1089.505n 0.0v 1099.495n 0.0v 1099.505n 0.0v 1109.495n 0.0v 1109.505n 0.0v 1119.495n 0.0v 1119.505n 1.8v 1129.495n 1.8v 1129.505n 1.8v 1139.495n 1.8v 1139.505n 1.8v 1149.495n 1.8v 1149.505n 1.8v 1159.495n 1.8v 1159.505n 1.8v 1169.495n 1.8v 1169.505n 0.0v 1179.495n 0.0v 1179.505n 0.0v 1189.495n 0.0v 1189.505n 0.0v 1199.495n 0.0v 1199.505n 1.8v 1209.495n 1.8v 1209.505n 1.8v 1219.495n 1.8v 1219.505n 1.8v 1229.495n 1.8v 1229.505n 1.8v 1239.495n 1.8v 1239.505n 1.8v 1249.495n 1.8v 1249.505n 1.8v 1259.495n 1.8v 1259.505n 0.0v 1269.495n 0.0v 1269.505n 0.0v 1279.495n 0.0v 1279.505n 0.0v 1289.495n 0.0v 1289.505n 0.0v 1299.495n 0.0v 1299.505n 0.0v 1309.495n 0.0v 1309.505n 0.0v 1319.495n 0.0v 1319.505n 0.0v 1329.495n 0.0v 1329.505n 0.0v 1339.495n 0.0v 1339.505n 1.8v 1349.495n 1.8v 1349.505n 0.0v 1359.495n 0.0v 1359.505n 1.8v 1369.495n 1.8v 1369.505n 0.0v 1379.495n 0.0v 1379.505n 0.0v 1389.495n 0.0v 1389.505n 0.0v 1399.495n 0.0v 1399.505n 0.0v 1409.495n 0.0v 1409.505n 0.0v 1419.495n 0.0v 1419.505n 0.0v 1429.495n 0.0v 1429.505n 0.0v 1439.495n 0.0v 1439.505n 0.0v 1449.495n 0.0v 1449.505n 0.0v 1459.495n 0.0v 1459.505n 0.0v 1469.495n 0.0v 1469.505n 1.8v 1479.495n 1.8v 1479.505n 1.8v 1489.495n 1.8v 1489.505n 1.8v 1499.495n 1.8v 1499.505n 1.8v 1509.495n 1.8v 1509.505n 1.8v 1519.495n 1.8v 1519.505n 1.8v 1529.495n 1.8v 1529.505n 1.8v 1539.495n 1.8v 1539.505n 1.8v 1549.495n 1.8v 1549.505n 0.0v 1559.495n 0.0v 1559.505n 1.8v 1569.495n 1.8v 1569.505n 1.8v 1579.495n 1.8v 1579.505n 1.8v 1589.495n 1.8v 1589.505n 0.0v 1599.495n 0.0v 1599.505n 0.0v 1609.495n 0.0v 1609.505n 0.0v 1619.495n 0.0v 1619.505n 0.0v 1629.495n 0.0v 1629.505n 0.0v 1639.495n 0.0v 1639.505n 1.8v 1649.495n 1.8v 1649.505n 1.8v 1659.495n 1.8v 1659.505n 1.8v 1669.495n 1.8v 1669.505n 1.8v 1679.495n 1.8v 1679.505n 1.8v 1689.495n 1.8v 1689.505n 1.8v 1699.495n 1.8v 1699.505n 1.8v 1709.495n 1.8v 1709.505n 1.8v 1719.495n 1.8v 1719.505n 1.8v 1729.495n 1.8v 1729.505n 1.8v 1739.495n 1.8v 1739.505n 1.8v 1749.495n 1.8v 1749.505n 1.8v 1759.495n 1.8v 1759.505n 1.8v 1769.495n 1.8v 1769.505n 0.0v 1779.495n 0.0v 1779.505n 0.0v 1789.495n 0.0v 1789.505n 0.0v 1799.495n 0.0v 1799.505n 1.8v 1809.495n 1.8v 1809.505n 0.0v 1819.495n 0.0v 1819.505n 0.0v 1829.495n 0.0v 1829.505n 0.0v 1839.495n 0.0v 1839.505n 0.0v 1849.495n 0.0v 1849.505n 0.0v 1859.495n 0.0v 1859.505n 0.0v 1869.495n 0.0v 1869.505n 0.0v 1879.495n 0.0v 1879.505n 0.0v 1889.495n 0.0v 1889.505n 0.0v 1899.495n 0.0v 1899.505n 0.0v 1909.495n 0.0v 1909.505n 1.8v 1919.495n 1.8v 1919.505n 1.8v 1929.495n 1.8v 1929.505n 1.8v 1939.495n 1.8v 1939.505n 1.8v 1949.495n 1.8v 1949.505n 1.8v 1959.495n 1.8v 1959.505n 1.8v 1969.495n 1.8v 1969.505n 1.8v 1979.495n 1.8v 1979.505n 1.8v 1989.495n 1.8v 1989.505n 1.8v 1999.495n 1.8v 1999.505n 1.8v 2009.495n 1.8v 2009.505n 1.8v 2019.495n 1.8v 2019.505n 1.8v 2029.495n 1.8v 2029.505n 1.8v 2039.495n 1.8v 2039.505n 1.8v 2049.495n 1.8v 2049.505n 1.8v )
* (time, data): [(0, 0), (10, 1), (20, 0), (30, 0), (40, 0), (50, 0), (60, 1), (70, 1), (80, 1), (90, 1), (100, 1), (110, 1), (120, 0), (130, 0), (140, 0), (150, 0), (160, 0), (170, 0), (180, 0), (190, 0), (200, 1), (210, 1), (220, 1), (230, 1), (240, 1), (250, 1), (260, 1), (270, 1), (280, 1), (290, 1), (300, 1), (310, 1), (320, 0), (330, 0), (340, 0), (350, 0), (360, 0), (370, 0), (380, 0), (390, 0), (400, 0), (410, 1), (420, 0), (430, 0), (440, 0), (450, 0), (460, 0), (470, 0), (480, 0), (490, 1), (500, 1), (510, 0), (520, 0), (530, 1), (540, 0), (550, 0), (560, 0), (570, 0), (580, 1), (590, 1), (600, 1), (610, 1), (620, 1), (630, 0), (640, 0), (650, 0), (660, 1), (670, 0), (680, 0), (690, 0), (700, 0), (710, 0), (720, 0), (730, 0), (740, 1), (750, 1), (760, 0), (770, 0), (780, 1), (790, 1), (800, 0), (810, 0), (820, 0), (830, 0), (840, 0), (850, 0), (860, 0), (870, 1), (880, 1), (890, 1), (900, 1), (910, 1), (920, 1), (930, 1), (940, 1), (950, 1), (960, 1), (970, 0), (980, 1), (990, 1), (1000, 1), (1010, 1), (1020, 0), (1030, 0), (1040, 0), (1050, 0), (1060, 0), (1070, 0), (1080, 0), (1090, 0), (1100, 0), (1110, 0), (1120, 0), (1130, 0), (1140, 1), (1150, 1), (1160, 1), (1170, 1), (1180, 1), (1190, 1), (1200, 0), (1210, 0), (1220, 0), (1230, 0), (1240, 1), (1250, 1), (1260, 0), (1270, 0), (1280, 0), (1290, 0), (1300, 0), (1310, 0), (1320, 0), (1330, 0), (1340, 0), (1350, 0), (1360, 0), (1370, 1), (1380, 1), (1390, 1), (1400, 1), (1410, 1), (1420, 1), (1430, 1), (1440, 0), (1450, 0), (1460, 0), (1470, 0), (1480, 0), (1490, 0), (1500, 0), (1510, 0), (1520, 0), (1530, 0), (1540, 0), (1550, 1), (1560, 0), (1570, 0), (1580, 0), (1590, 0), (1600, 0), (1610, 0), (1620, 0), (1630, 0), (1640, 1), (1650, 1), (1660, 1), (1670, 1), (1680, 1), (1690, 1), (1700, 1), (1710, 1), (1720, 1), (1730, 1), (1740, 1), (1750, 1), (1760, 1), (1770, 1), (1780, 0), (1790, 1), (1800, 1), (1810, 1), (1820, 1), (1830, 1), (1840, 1), (1850, 1), (1860, 1), (1870, 1), (1880, 1), (1890, 1), (1900, 1), (1910, 0), (1920, 0), (1930, 1), (1940, 1), (1950, 1), (1960, 1), (1970, 1), (1980, 1), (1990, 1), (2000, 1), (2010, 0), (2020, 0), (2030, 0), (2040, 0), (2050, 0)]
Vdin0_24  din0_24  0 PWL (0n 0.0v 9.495n 0.0v 9.505n 1.8v 19.495n 1.8v 19.505n 0.0v 29.495n 0.0v 29.505n 0.0v 39.495n 0.0v 39.505n 0.0v 49.495n 0.0v 49.505n 0.0v 59.495n 0.0v 59.505n 1.8v 69.495n 1.8v 69.505n 1.8v 79.495n 1.8v 79.505n 1.8v 89.495n 1.8v 89.505n 1.8v 99.495n 1.8v 99.505n 1.8v 109.495n 1.8v 109.505n 1.8v 119.495n 1.8v 119.505n 0.0v 129.495n 0.0v 129.505n 0.0v 139.495n 0.0v 139.505n 0.0v 149.495n 0.0v 149.505n 0.0v 159.495n 0.0v 159.505n 0.0v 169.495n 0.0v 169.505n 0.0v 179.495n 0.0v 179.505n 0.0v 189.495n 0.0v 189.505n 0.0v 199.495n 0.0v 199.505n 1.8v 209.495n 1.8v 209.505n 1.8v 219.495n 1.8v 219.505n 1.8v 229.495n 1.8v 229.505n 1.8v 239.495n 1.8v 239.505n 1.8v 249.495n 1.8v 249.505n 1.8v 259.495n 1.8v 259.505n 1.8v 269.495n 1.8v 269.505n 1.8v 279.495n 1.8v 279.505n 1.8v 289.495n 1.8v 289.505n 1.8v 299.495n 1.8v 299.505n 1.8v 309.495n 1.8v 309.505n 1.8v 319.495n 1.8v 319.505n 0.0v 329.495n 0.0v 329.505n 0.0v 339.495n 0.0v 339.505n 0.0v 349.495n 0.0v 349.505n 0.0v 359.495n 0.0v 359.505n 0.0v 369.495n 0.0v 369.505n 0.0v 379.495n 0.0v 379.505n 0.0v 389.495n 0.0v 389.505n 0.0v 399.495n 0.0v 399.505n 0.0v 409.495n 0.0v 409.505n 1.8v 419.495n 1.8v 419.505n 0.0v 429.495n 0.0v 429.505n 0.0v 439.495n 0.0v 439.505n 0.0v 449.495n 0.0v 449.505n 0.0v 459.495n 0.0v 459.505n 0.0v 469.495n 0.0v 469.505n 0.0v 479.495n 0.0v 479.505n 0.0v 489.495n 0.0v 489.505n 1.8v 499.495n 1.8v 499.505n 1.8v 509.495n 1.8v 509.505n 0.0v 519.495n 0.0v 519.505n 0.0v 529.495n 0.0v 529.505n 1.8v 539.495n 1.8v 539.505n 0.0v 549.495n 0.0v 549.505n 0.0v 559.495n 0.0v 559.505n 0.0v 569.495n 0.0v 569.505n 0.0v 579.495n 0.0v 579.505n 1.8v 589.495n 1.8v 589.505n 1.8v 599.495n 1.8v 599.505n 1.8v 609.495n 1.8v 609.505n 1.8v 619.495n 1.8v 619.505n 1.8v 629.495n 1.8v 629.505n 0.0v 639.495n 0.0v 639.505n 0.0v 649.495n 0.0v 649.505n 0.0v 659.495n 0.0v 659.505n 1.8v 669.495n 1.8v 669.505n 0.0v 679.495n 0.0v 679.505n 0.0v 689.495n 0.0v 689.505n 0.0v 699.495n 0.0v 699.505n 0.0v 709.495n 0.0v 709.505n 0.0v 719.495n 0.0v 719.505n 0.0v 729.495n 0.0v 729.505n 0.0v 739.495n 0.0v 739.505n 1.8v 749.495n 1.8v 749.505n 1.8v 759.495n 1.8v 759.505n 0.0v 769.495n 0.0v 769.505n 0.0v 779.495n 0.0v 779.505n 1.8v 789.495n 1.8v 789.505n 1.8v 799.495n 1.8v 799.505n 0.0v 809.495n 0.0v 809.505n 0.0v 819.495n 0.0v 819.505n 0.0v 829.495n 0.0v 829.505n 0.0v 839.495n 0.0v 839.505n 0.0v 849.495n 0.0v 849.505n 0.0v 859.495n 0.0v 859.505n 0.0v 869.495n 0.0v 869.505n 1.8v 879.495n 1.8v 879.505n 1.8v 889.495n 1.8v 889.505n 1.8v 899.495n 1.8v 899.505n 1.8v 909.495n 1.8v 909.505n 1.8v 919.495n 1.8v 919.505n 1.8v 929.495n 1.8v 929.505n 1.8v 939.495n 1.8v 939.505n 1.8v 949.495n 1.8v 949.505n 1.8v 959.495n 1.8v 959.505n 1.8v 969.495n 1.8v 969.505n 0.0v 979.495n 0.0v 979.505n 1.8v 989.495n 1.8v 989.505n 1.8v 999.495n 1.8v 999.505n 1.8v 1009.495n 1.8v 1009.505n 1.8v 1019.495n 1.8v 1019.505n 0.0v 1029.495n 0.0v 1029.505n 0.0v 1039.495n 0.0v 1039.505n 0.0v 1049.495n 0.0v 1049.505n 0.0v 1059.495n 0.0v 1059.505n 0.0v 1069.495n 0.0v 1069.505n 0.0v 1079.495n 0.0v 1079.505n 0.0v 1089.495n 0.0v 1089.505n 0.0v 1099.495n 0.0v 1099.505n 0.0v 1109.495n 0.0v 1109.505n 0.0v 1119.495n 0.0v 1119.505n 0.0v 1129.495n 0.0v 1129.505n 0.0v 1139.495n 0.0v 1139.505n 1.8v 1149.495n 1.8v 1149.505n 1.8v 1159.495n 1.8v 1159.505n 1.8v 1169.495n 1.8v 1169.505n 1.8v 1179.495n 1.8v 1179.505n 1.8v 1189.495n 1.8v 1189.505n 1.8v 1199.495n 1.8v 1199.505n 0.0v 1209.495n 0.0v 1209.505n 0.0v 1219.495n 0.0v 1219.505n 0.0v 1229.495n 0.0v 1229.505n 0.0v 1239.495n 0.0v 1239.505n 1.8v 1249.495n 1.8v 1249.505n 1.8v 1259.495n 1.8v 1259.505n 0.0v 1269.495n 0.0v 1269.505n 0.0v 1279.495n 0.0v 1279.505n 0.0v 1289.495n 0.0v 1289.505n 0.0v 1299.495n 0.0v 1299.505n 0.0v 1309.495n 0.0v 1309.505n 0.0v 1319.495n 0.0v 1319.505n 0.0v 1329.495n 0.0v 1329.505n 0.0v 1339.495n 0.0v 1339.505n 0.0v 1349.495n 0.0v 1349.505n 0.0v 1359.495n 0.0v 1359.505n 0.0v 1369.495n 0.0v 1369.505n 1.8v 1379.495n 1.8v 1379.505n 1.8v 1389.495n 1.8v 1389.505n 1.8v 1399.495n 1.8v 1399.505n 1.8v 1409.495n 1.8v 1409.505n 1.8v 1419.495n 1.8v 1419.505n 1.8v 1429.495n 1.8v 1429.505n 1.8v 1439.495n 1.8v 1439.505n 0.0v 1449.495n 0.0v 1449.505n 0.0v 1459.495n 0.0v 1459.505n 0.0v 1469.495n 0.0v 1469.505n 0.0v 1479.495n 0.0v 1479.505n 0.0v 1489.495n 0.0v 1489.505n 0.0v 1499.495n 0.0v 1499.505n 0.0v 1509.495n 0.0v 1509.505n 0.0v 1519.495n 0.0v 1519.505n 0.0v 1529.495n 0.0v 1529.505n 0.0v 1539.495n 0.0v 1539.505n 0.0v 1549.495n 0.0v 1549.505n 1.8v 1559.495n 1.8v 1559.505n 0.0v 1569.495n 0.0v 1569.505n 0.0v 1579.495n 0.0v 1579.505n 0.0v 1589.495n 0.0v 1589.505n 0.0v 1599.495n 0.0v 1599.505n 0.0v 1609.495n 0.0v 1609.505n 0.0v 1619.495n 0.0v 1619.505n 0.0v 1629.495n 0.0v 1629.505n 0.0v 1639.495n 0.0v 1639.505n 1.8v 1649.495n 1.8v 1649.505n 1.8v 1659.495n 1.8v 1659.505n 1.8v 1669.495n 1.8v 1669.505n 1.8v 1679.495n 1.8v 1679.505n 1.8v 1689.495n 1.8v 1689.505n 1.8v 1699.495n 1.8v 1699.505n 1.8v 1709.495n 1.8v 1709.505n 1.8v 1719.495n 1.8v 1719.505n 1.8v 1729.495n 1.8v 1729.505n 1.8v 1739.495n 1.8v 1739.505n 1.8v 1749.495n 1.8v 1749.505n 1.8v 1759.495n 1.8v 1759.505n 1.8v 1769.495n 1.8v 1769.505n 1.8v 1779.495n 1.8v 1779.505n 0.0v 1789.495n 0.0v 1789.505n 1.8v 1799.495n 1.8v 1799.505n 1.8v 1809.495n 1.8v 1809.505n 1.8v 1819.495n 1.8v 1819.505n 1.8v 1829.495n 1.8v 1829.505n 1.8v 1839.495n 1.8v 1839.505n 1.8v 1849.495n 1.8v 1849.505n 1.8v 1859.495n 1.8v 1859.505n 1.8v 1869.495n 1.8v 1869.505n 1.8v 1879.495n 1.8v 1879.505n 1.8v 1889.495n 1.8v 1889.505n 1.8v 1899.495n 1.8v 1899.505n 1.8v 1909.495n 1.8v 1909.505n 0.0v 1919.495n 0.0v 1919.505n 0.0v 1929.495n 0.0v 1929.505n 1.8v 1939.495n 1.8v 1939.505n 1.8v 1949.495n 1.8v 1949.505n 1.8v 1959.495n 1.8v 1959.505n 1.8v 1969.495n 1.8v 1969.505n 1.8v 1979.495n 1.8v 1979.505n 1.8v 1989.495n 1.8v 1989.505n 1.8v 1999.495n 1.8v 1999.505n 1.8v 2009.495n 1.8v 2009.505n 0.0v 2019.495n 0.0v 2019.505n 0.0v 2029.495n 0.0v 2029.505n 0.0v 2039.495n 0.0v 2039.505n 0.0v 2049.495n 0.0v 2049.505n 0.0v )
* (time, data): [(0, 0), (10, 0), (20, 1), (30, 1), (40, 1), (50, 1), (60, 0), (70, 0), (80, 0), (90, 1), (100, 1), (110, 1), (120, 0), (130, 0), (140, 0), (150, 0), (160, 0), (170, 0), (180, 0), (190, 0), (200, 1), (210, 1), (220, 0), (230, 0), (240, 0), (250, 0), (260, 0), (270, 0), (280, 0), (290, 0), (300, 0), (310, 0), (320, 0), (330, 0), (340, 0), (350, 0), (360, 0), (370, 0), (380, 0), (390, 0), (400, 0), (410, 1), (420, 0), (430, 0), (440, 1), (450, 1), (460, 1), (470, 1), (480, 1), (490, 0), (500, 0), (510, 1), (520, 1), (530, 0), (540, 0), (550, 0), (560, 0), (570, 0), (580, 0), (590, 0), (600, 0), (610, 0), (620, 0), (630, 0), (640, 0), (650, 0), (660, 0), (670, 0), (680, 0), (690, 0), (700, 0), (710, 0), (720, 0), (730, 1), (740, 0), (750, 0), (760, 1), (770, 1), (780, 0), (790, 0), (800, 0), (810, 0), (820, 0), (830, 0), (840, 0), (850, 0), (860, 0), (870, 0), (880, 0), (890, 0), (900, 0), (910, 0), (920, 0), (930, 0), (940, 0), (950, 0), (960, 0), (970, 0), (980, 0), (990, 0), (1000, 0), (1010, 0), (1020, 0), (1030, 0), (1040, 0), (1050, 0), (1060, 0), (1070, 0), (1080, 0), (1090, 0), (1100, 0), (1110, 0), (1120, 1), (1130, 1), (1140, 1), (1150, 1), (1160, 1), (1170, 1), (1180, 1), (1190, 1), (1200, 0), (1210, 0), (1220, 0), (1230, 1), (1240, 0), (1250, 0), (1260, 0), (1270, 0), (1280, 0), (1290, 0), (1300, 0), (1310, 0), (1320, 0), (1330, 1), (1340, 1), (1350, 1), (1360, 0), (1370, 1), (1380, 1), (1390, 1), (1400, 1), (1410, 1), (1420, 1), (1430, 1), (1440, 0), (1450, 0), (1460, 1), (1470, 0), (1480, 0), (1490, 0), (1500, 0), (1510, 0), (1520, 0), (1530, 0), (1540, 0), (1550, 0), (1560, 1), (1570, 1), (1580, 1), (1590, 1), (1600, 1), (1610, 1), (1620, 1), (1630, 1), (1640, 0), (1650, 0), (1660, 0), (1670, 0), (1680, 0), (1690, 0), (1700, 0), (1710, 0), (1720, 0), (1730, 0), (1740, 0), (1750, 0), (1760, 0), (1770, 0), (1780, 0), (1790, 1), (1800, 1), (1810, 0), (1820, 0), (1830, 0), (1840, 0), (1850, 0), (1860, 0), (1870, 0), (1880, 1), (1890, 1), (1900, 0), (1910, 1), (1920, 1), (1930, 1), (1940, 1), (1950, 1), (1960, 1), (1970, 1), (1980, 0), (1990, 0), (2000, 0), (2010, 1), (2020, 1), (2030, 1), (2040, 1), (2050, 1)]
Vdin0_25  din0_25  0 PWL (0n 0.0v 9.495n 0.0v 9.505n 0.0v 19.495n 0.0v 19.505n 1.8v 29.495n 1.8v 29.505n 1.8v 39.495n 1.8v 39.505n 1.8v 49.495n 1.8v 49.505n 1.8v 59.495n 1.8v 59.505n 0.0v 69.495n 0.0v 69.505n 0.0v 79.495n 0.0v 79.505n 0.0v 89.495n 0.0v 89.505n 1.8v 99.495n 1.8v 99.505n 1.8v 109.495n 1.8v 109.505n 1.8v 119.495n 1.8v 119.505n 0.0v 129.495n 0.0v 129.505n 0.0v 139.495n 0.0v 139.505n 0.0v 149.495n 0.0v 149.505n 0.0v 159.495n 0.0v 159.505n 0.0v 169.495n 0.0v 169.505n 0.0v 179.495n 0.0v 179.505n 0.0v 189.495n 0.0v 189.505n 0.0v 199.495n 0.0v 199.505n 1.8v 209.495n 1.8v 209.505n 1.8v 219.495n 1.8v 219.505n 0.0v 229.495n 0.0v 229.505n 0.0v 239.495n 0.0v 239.505n 0.0v 249.495n 0.0v 249.505n 0.0v 259.495n 0.0v 259.505n 0.0v 269.495n 0.0v 269.505n 0.0v 279.495n 0.0v 279.505n 0.0v 289.495n 0.0v 289.505n 0.0v 299.495n 0.0v 299.505n 0.0v 309.495n 0.0v 309.505n 0.0v 319.495n 0.0v 319.505n 0.0v 329.495n 0.0v 329.505n 0.0v 339.495n 0.0v 339.505n 0.0v 349.495n 0.0v 349.505n 0.0v 359.495n 0.0v 359.505n 0.0v 369.495n 0.0v 369.505n 0.0v 379.495n 0.0v 379.505n 0.0v 389.495n 0.0v 389.505n 0.0v 399.495n 0.0v 399.505n 0.0v 409.495n 0.0v 409.505n 1.8v 419.495n 1.8v 419.505n 0.0v 429.495n 0.0v 429.505n 0.0v 439.495n 0.0v 439.505n 1.8v 449.495n 1.8v 449.505n 1.8v 459.495n 1.8v 459.505n 1.8v 469.495n 1.8v 469.505n 1.8v 479.495n 1.8v 479.505n 1.8v 489.495n 1.8v 489.505n 0.0v 499.495n 0.0v 499.505n 0.0v 509.495n 0.0v 509.505n 1.8v 519.495n 1.8v 519.505n 1.8v 529.495n 1.8v 529.505n 0.0v 539.495n 0.0v 539.505n 0.0v 549.495n 0.0v 549.505n 0.0v 559.495n 0.0v 559.505n 0.0v 569.495n 0.0v 569.505n 0.0v 579.495n 0.0v 579.505n 0.0v 589.495n 0.0v 589.505n 0.0v 599.495n 0.0v 599.505n 0.0v 609.495n 0.0v 609.505n 0.0v 619.495n 0.0v 619.505n 0.0v 629.495n 0.0v 629.505n 0.0v 639.495n 0.0v 639.505n 0.0v 649.495n 0.0v 649.505n 0.0v 659.495n 0.0v 659.505n 0.0v 669.495n 0.0v 669.505n 0.0v 679.495n 0.0v 679.505n 0.0v 689.495n 0.0v 689.505n 0.0v 699.495n 0.0v 699.505n 0.0v 709.495n 0.0v 709.505n 0.0v 719.495n 0.0v 719.505n 0.0v 729.495n 0.0v 729.505n 1.8v 739.495n 1.8v 739.505n 0.0v 749.495n 0.0v 749.505n 0.0v 759.495n 0.0v 759.505n 1.8v 769.495n 1.8v 769.505n 1.8v 779.495n 1.8v 779.505n 0.0v 789.495n 0.0v 789.505n 0.0v 799.495n 0.0v 799.505n 0.0v 809.495n 0.0v 809.505n 0.0v 819.495n 0.0v 819.505n 0.0v 829.495n 0.0v 829.505n 0.0v 839.495n 0.0v 839.505n 0.0v 849.495n 0.0v 849.505n 0.0v 859.495n 0.0v 859.505n 0.0v 869.495n 0.0v 869.505n 0.0v 879.495n 0.0v 879.505n 0.0v 889.495n 0.0v 889.505n 0.0v 899.495n 0.0v 899.505n 0.0v 909.495n 0.0v 909.505n 0.0v 919.495n 0.0v 919.505n 0.0v 929.495n 0.0v 929.505n 0.0v 939.495n 0.0v 939.505n 0.0v 949.495n 0.0v 949.505n 0.0v 959.495n 0.0v 959.505n 0.0v 969.495n 0.0v 969.505n 0.0v 979.495n 0.0v 979.505n 0.0v 989.495n 0.0v 989.505n 0.0v 999.495n 0.0v 999.505n 0.0v 1009.495n 0.0v 1009.505n 0.0v 1019.495n 0.0v 1019.505n 0.0v 1029.495n 0.0v 1029.505n 0.0v 1039.495n 0.0v 1039.505n 0.0v 1049.495n 0.0v 1049.505n 0.0v 1059.495n 0.0v 1059.505n 0.0v 1069.495n 0.0v 1069.505n 0.0v 1079.495n 0.0v 1079.505n 0.0v 1089.495n 0.0v 1089.505n 0.0v 1099.495n 0.0v 1099.505n 0.0v 1109.495n 0.0v 1109.505n 0.0v 1119.495n 0.0v 1119.505n 1.8v 1129.495n 1.8v 1129.505n 1.8v 1139.495n 1.8v 1139.505n 1.8v 1149.495n 1.8v 1149.505n 1.8v 1159.495n 1.8v 1159.505n 1.8v 1169.495n 1.8v 1169.505n 1.8v 1179.495n 1.8v 1179.505n 1.8v 1189.495n 1.8v 1189.505n 1.8v 1199.495n 1.8v 1199.505n 0.0v 1209.495n 0.0v 1209.505n 0.0v 1219.495n 0.0v 1219.505n 0.0v 1229.495n 0.0v 1229.505n 1.8v 1239.495n 1.8v 1239.505n 0.0v 1249.495n 0.0v 1249.505n 0.0v 1259.495n 0.0v 1259.505n 0.0v 1269.495n 0.0v 1269.505n 0.0v 1279.495n 0.0v 1279.505n 0.0v 1289.495n 0.0v 1289.505n 0.0v 1299.495n 0.0v 1299.505n 0.0v 1309.495n 0.0v 1309.505n 0.0v 1319.495n 0.0v 1319.505n 0.0v 1329.495n 0.0v 1329.505n 1.8v 1339.495n 1.8v 1339.505n 1.8v 1349.495n 1.8v 1349.505n 1.8v 1359.495n 1.8v 1359.505n 0.0v 1369.495n 0.0v 1369.505n 1.8v 1379.495n 1.8v 1379.505n 1.8v 1389.495n 1.8v 1389.505n 1.8v 1399.495n 1.8v 1399.505n 1.8v 1409.495n 1.8v 1409.505n 1.8v 1419.495n 1.8v 1419.505n 1.8v 1429.495n 1.8v 1429.505n 1.8v 1439.495n 1.8v 1439.505n 0.0v 1449.495n 0.0v 1449.505n 0.0v 1459.495n 0.0v 1459.505n 1.8v 1469.495n 1.8v 1469.505n 0.0v 1479.495n 0.0v 1479.505n 0.0v 1489.495n 0.0v 1489.505n 0.0v 1499.495n 0.0v 1499.505n 0.0v 1509.495n 0.0v 1509.505n 0.0v 1519.495n 0.0v 1519.505n 0.0v 1529.495n 0.0v 1529.505n 0.0v 1539.495n 0.0v 1539.505n 0.0v 1549.495n 0.0v 1549.505n 0.0v 1559.495n 0.0v 1559.505n 1.8v 1569.495n 1.8v 1569.505n 1.8v 1579.495n 1.8v 1579.505n 1.8v 1589.495n 1.8v 1589.505n 1.8v 1599.495n 1.8v 1599.505n 1.8v 1609.495n 1.8v 1609.505n 1.8v 1619.495n 1.8v 1619.505n 1.8v 1629.495n 1.8v 1629.505n 1.8v 1639.495n 1.8v 1639.505n 0.0v 1649.495n 0.0v 1649.505n 0.0v 1659.495n 0.0v 1659.505n 0.0v 1669.495n 0.0v 1669.505n 0.0v 1679.495n 0.0v 1679.505n 0.0v 1689.495n 0.0v 1689.505n 0.0v 1699.495n 0.0v 1699.505n 0.0v 1709.495n 0.0v 1709.505n 0.0v 1719.495n 0.0v 1719.505n 0.0v 1729.495n 0.0v 1729.505n 0.0v 1739.495n 0.0v 1739.505n 0.0v 1749.495n 0.0v 1749.505n 0.0v 1759.495n 0.0v 1759.505n 0.0v 1769.495n 0.0v 1769.505n 0.0v 1779.495n 0.0v 1779.505n 0.0v 1789.495n 0.0v 1789.505n 1.8v 1799.495n 1.8v 1799.505n 1.8v 1809.495n 1.8v 1809.505n 0.0v 1819.495n 0.0v 1819.505n 0.0v 1829.495n 0.0v 1829.505n 0.0v 1839.495n 0.0v 1839.505n 0.0v 1849.495n 0.0v 1849.505n 0.0v 1859.495n 0.0v 1859.505n 0.0v 1869.495n 0.0v 1869.505n 0.0v 1879.495n 0.0v 1879.505n 1.8v 1889.495n 1.8v 1889.505n 1.8v 1899.495n 1.8v 1899.505n 0.0v 1909.495n 0.0v 1909.505n 1.8v 1919.495n 1.8v 1919.505n 1.8v 1929.495n 1.8v 1929.505n 1.8v 1939.495n 1.8v 1939.505n 1.8v 1949.495n 1.8v 1949.505n 1.8v 1959.495n 1.8v 1959.505n 1.8v 1969.495n 1.8v 1969.505n 1.8v 1979.495n 1.8v 1979.505n 0.0v 1989.495n 0.0v 1989.505n 0.0v 1999.495n 0.0v 1999.505n 0.0v 2009.495n 0.0v 2009.505n 1.8v 2019.495n 1.8v 2019.505n 1.8v 2029.495n 1.8v 2029.505n 1.8v 2039.495n 1.8v 2039.505n 1.8v 2049.495n 1.8v 2049.505n 1.8v )
* (time, data): [(0, 0), (10, 0), (20, 0), (30, 1), (40, 1), (50, 1), (60, 1), (70, 1), (80, 1), (90, 1), (100, 1), (110, 1), (120, 0), (130, 0), (140, 0), (150, 0), (160, 0), (170, 0), (180, 0), (190, 0), (200, 1), (210, 1), (220, 0), (230, 0), (240, 0), (250, 0), (260, 0), (270, 0), (280, 0), (290, 0), (300, 0), (310, 0), (320, 1), (330, 1), (340, 1), (350, 1), (360, 0), (370, 0), (380, 0), (390, 0), (400, 0), (410, 1), (420, 1), (430, 1), (440, 1), (450, 1), (460, 1), (470, 1), (480, 1), (490, 1), (500, 1), (510, 0), (520, 0), (530, 1), (540, 0), (550, 1), (560, 1), (570, 1), (580, 1), (590, 0), (600, 0), (610, 0), (620, 0), (630, 0), (640, 0), (650, 0), (660, 0), (670, 1), (680, 1), (690, 1), (700, 0), (710, 0), (720, 0), (730, 1), (740, 1), (750, 1), (760, 0), (770, 0), (780, 1), (790, 1), (800, 1), (810, 1), (820, 1), (830, 1), (840, 0), (850, 0), (860, 0), (870, 1), (880, 1), (890, 1), (900, 1), (910, 1), (920, 1), (930, 1), (940, 1), (950, 1), (960, 1), (970, 0), (980, 1), (990, 1), (1000, 0), (1010, 0), (1020, 1), (1030, 1), (1040, 1), (1050, 1), (1060, 1), (1070, 1), (1080, 1), (1090, 1), (1100, 1), (1110, 1), (1120, 0), (1130, 0), (1140, 0), (1150, 0), (1160, 0), (1170, 1), (1180, 1), (1190, 1), (1200, 1), (1210, 1), (1220, 1), (1230, 0), (1240, 1), (1250, 1), (1260, 0), (1270, 0), (1280, 0), (1290, 0), (1300, 0), (1310, 0), (1320, 1), (1330, 1), (1340, 0), (1350, 0), (1360, 0), (1370, 0), (1380, 0), (1390, 0), (1400, 0), (1410, 0), (1420, 0), (1430, 0), (1440, 0), (1450, 0), (1460, 0), (1470, 1), (1480, 1), (1490, 1), (1500, 1), (1510, 1), (1520, 1), (1530, 1), (1540, 1), (1550, 1), (1560, 1), (1570, 1), (1580, 1), (1590, 0), (1600, 0), (1610, 0), (1620, 0), (1630, 0), (1640, 0), (1650, 0), (1660, 0), (1670, 0), (1680, 0), (1690, 0), (1700, 0), (1710, 0), (1720, 0), (1730, 0), (1740, 0), (1750, 0), (1760, 0), (1770, 1), (1780, 0), (1790, 1), (1800, 0), (1810, 0), (1820, 0), (1830, 0), (1840, 0), (1850, 0), (1860, 0), (1870, 0), (1880, 1), (1890, 1), (1900, 0), (1910, 0), (1920, 0), (1930, 1), (1940, 1), (1950, 1), (1960, 1), (1970, 1), (1980, 0), (1990, 0), (2000, 0), (2010, 1), (2020, 1), (2030, 1), (2040, 1), (2050, 1)]
Vdin0_26  din0_26  0 PWL (0n 0.0v 9.495n 0.0v 9.505n 0.0v 19.495n 0.0v 19.505n 0.0v 29.495n 0.0v 29.505n 1.8v 39.495n 1.8v 39.505n 1.8v 49.495n 1.8v 49.505n 1.8v 59.495n 1.8v 59.505n 1.8v 69.495n 1.8v 69.505n 1.8v 79.495n 1.8v 79.505n 1.8v 89.495n 1.8v 89.505n 1.8v 99.495n 1.8v 99.505n 1.8v 109.495n 1.8v 109.505n 1.8v 119.495n 1.8v 119.505n 0.0v 129.495n 0.0v 129.505n 0.0v 139.495n 0.0v 139.505n 0.0v 149.495n 0.0v 149.505n 0.0v 159.495n 0.0v 159.505n 0.0v 169.495n 0.0v 169.505n 0.0v 179.495n 0.0v 179.505n 0.0v 189.495n 0.0v 189.505n 0.0v 199.495n 0.0v 199.505n 1.8v 209.495n 1.8v 209.505n 1.8v 219.495n 1.8v 219.505n 0.0v 229.495n 0.0v 229.505n 0.0v 239.495n 0.0v 239.505n 0.0v 249.495n 0.0v 249.505n 0.0v 259.495n 0.0v 259.505n 0.0v 269.495n 0.0v 269.505n 0.0v 279.495n 0.0v 279.505n 0.0v 289.495n 0.0v 289.505n 0.0v 299.495n 0.0v 299.505n 0.0v 309.495n 0.0v 309.505n 0.0v 319.495n 0.0v 319.505n 1.8v 329.495n 1.8v 329.505n 1.8v 339.495n 1.8v 339.505n 1.8v 349.495n 1.8v 349.505n 1.8v 359.495n 1.8v 359.505n 0.0v 369.495n 0.0v 369.505n 0.0v 379.495n 0.0v 379.505n 0.0v 389.495n 0.0v 389.505n 0.0v 399.495n 0.0v 399.505n 0.0v 409.495n 0.0v 409.505n 1.8v 419.495n 1.8v 419.505n 1.8v 429.495n 1.8v 429.505n 1.8v 439.495n 1.8v 439.505n 1.8v 449.495n 1.8v 449.505n 1.8v 459.495n 1.8v 459.505n 1.8v 469.495n 1.8v 469.505n 1.8v 479.495n 1.8v 479.505n 1.8v 489.495n 1.8v 489.505n 1.8v 499.495n 1.8v 499.505n 1.8v 509.495n 1.8v 509.505n 0.0v 519.495n 0.0v 519.505n 0.0v 529.495n 0.0v 529.505n 1.8v 539.495n 1.8v 539.505n 0.0v 549.495n 0.0v 549.505n 1.8v 559.495n 1.8v 559.505n 1.8v 569.495n 1.8v 569.505n 1.8v 579.495n 1.8v 579.505n 1.8v 589.495n 1.8v 589.505n 0.0v 599.495n 0.0v 599.505n 0.0v 609.495n 0.0v 609.505n 0.0v 619.495n 0.0v 619.505n 0.0v 629.495n 0.0v 629.505n 0.0v 639.495n 0.0v 639.505n 0.0v 649.495n 0.0v 649.505n 0.0v 659.495n 0.0v 659.505n 0.0v 669.495n 0.0v 669.505n 1.8v 679.495n 1.8v 679.505n 1.8v 689.495n 1.8v 689.505n 1.8v 699.495n 1.8v 699.505n 0.0v 709.495n 0.0v 709.505n 0.0v 719.495n 0.0v 719.505n 0.0v 729.495n 0.0v 729.505n 1.8v 739.495n 1.8v 739.505n 1.8v 749.495n 1.8v 749.505n 1.8v 759.495n 1.8v 759.505n 0.0v 769.495n 0.0v 769.505n 0.0v 779.495n 0.0v 779.505n 1.8v 789.495n 1.8v 789.505n 1.8v 799.495n 1.8v 799.505n 1.8v 809.495n 1.8v 809.505n 1.8v 819.495n 1.8v 819.505n 1.8v 829.495n 1.8v 829.505n 1.8v 839.495n 1.8v 839.505n 0.0v 849.495n 0.0v 849.505n 0.0v 859.495n 0.0v 859.505n 0.0v 869.495n 0.0v 869.505n 1.8v 879.495n 1.8v 879.505n 1.8v 889.495n 1.8v 889.505n 1.8v 899.495n 1.8v 899.505n 1.8v 909.495n 1.8v 909.505n 1.8v 919.495n 1.8v 919.505n 1.8v 929.495n 1.8v 929.505n 1.8v 939.495n 1.8v 939.505n 1.8v 949.495n 1.8v 949.505n 1.8v 959.495n 1.8v 959.505n 1.8v 969.495n 1.8v 969.505n 0.0v 979.495n 0.0v 979.505n 1.8v 989.495n 1.8v 989.505n 1.8v 999.495n 1.8v 999.505n 0.0v 1009.495n 0.0v 1009.505n 0.0v 1019.495n 0.0v 1019.505n 1.8v 1029.495n 1.8v 1029.505n 1.8v 1039.495n 1.8v 1039.505n 1.8v 1049.495n 1.8v 1049.505n 1.8v 1059.495n 1.8v 1059.505n 1.8v 1069.495n 1.8v 1069.505n 1.8v 1079.495n 1.8v 1079.505n 1.8v 1089.495n 1.8v 1089.505n 1.8v 1099.495n 1.8v 1099.505n 1.8v 1109.495n 1.8v 1109.505n 1.8v 1119.495n 1.8v 1119.505n 0.0v 1129.495n 0.0v 1129.505n 0.0v 1139.495n 0.0v 1139.505n 0.0v 1149.495n 0.0v 1149.505n 0.0v 1159.495n 0.0v 1159.505n 0.0v 1169.495n 0.0v 1169.505n 1.8v 1179.495n 1.8v 1179.505n 1.8v 1189.495n 1.8v 1189.505n 1.8v 1199.495n 1.8v 1199.505n 1.8v 1209.495n 1.8v 1209.505n 1.8v 1219.495n 1.8v 1219.505n 1.8v 1229.495n 1.8v 1229.505n 0.0v 1239.495n 0.0v 1239.505n 1.8v 1249.495n 1.8v 1249.505n 1.8v 1259.495n 1.8v 1259.505n 0.0v 1269.495n 0.0v 1269.505n 0.0v 1279.495n 0.0v 1279.505n 0.0v 1289.495n 0.0v 1289.505n 0.0v 1299.495n 0.0v 1299.505n 0.0v 1309.495n 0.0v 1309.505n 0.0v 1319.495n 0.0v 1319.505n 1.8v 1329.495n 1.8v 1329.505n 1.8v 1339.495n 1.8v 1339.505n 0.0v 1349.495n 0.0v 1349.505n 0.0v 1359.495n 0.0v 1359.505n 0.0v 1369.495n 0.0v 1369.505n 0.0v 1379.495n 0.0v 1379.505n 0.0v 1389.495n 0.0v 1389.505n 0.0v 1399.495n 0.0v 1399.505n 0.0v 1409.495n 0.0v 1409.505n 0.0v 1419.495n 0.0v 1419.505n 0.0v 1429.495n 0.0v 1429.505n 0.0v 1439.495n 0.0v 1439.505n 0.0v 1449.495n 0.0v 1449.505n 0.0v 1459.495n 0.0v 1459.505n 0.0v 1469.495n 0.0v 1469.505n 1.8v 1479.495n 1.8v 1479.505n 1.8v 1489.495n 1.8v 1489.505n 1.8v 1499.495n 1.8v 1499.505n 1.8v 1509.495n 1.8v 1509.505n 1.8v 1519.495n 1.8v 1519.505n 1.8v 1529.495n 1.8v 1529.505n 1.8v 1539.495n 1.8v 1539.505n 1.8v 1549.495n 1.8v 1549.505n 1.8v 1559.495n 1.8v 1559.505n 1.8v 1569.495n 1.8v 1569.505n 1.8v 1579.495n 1.8v 1579.505n 1.8v 1589.495n 1.8v 1589.505n 0.0v 1599.495n 0.0v 1599.505n 0.0v 1609.495n 0.0v 1609.505n 0.0v 1619.495n 0.0v 1619.505n 0.0v 1629.495n 0.0v 1629.505n 0.0v 1639.495n 0.0v 1639.505n 0.0v 1649.495n 0.0v 1649.505n 0.0v 1659.495n 0.0v 1659.505n 0.0v 1669.495n 0.0v 1669.505n 0.0v 1679.495n 0.0v 1679.505n 0.0v 1689.495n 0.0v 1689.505n 0.0v 1699.495n 0.0v 1699.505n 0.0v 1709.495n 0.0v 1709.505n 0.0v 1719.495n 0.0v 1719.505n 0.0v 1729.495n 0.0v 1729.505n 0.0v 1739.495n 0.0v 1739.505n 0.0v 1749.495n 0.0v 1749.505n 0.0v 1759.495n 0.0v 1759.505n 0.0v 1769.495n 0.0v 1769.505n 1.8v 1779.495n 1.8v 1779.505n 0.0v 1789.495n 0.0v 1789.505n 1.8v 1799.495n 1.8v 1799.505n 0.0v 1809.495n 0.0v 1809.505n 0.0v 1819.495n 0.0v 1819.505n 0.0v 1829.495n 0.0v 1829.505n 0.0v 1839.495n 0.0v 1839.505n 0.0v 1849.495n 0.0v 1849.505n 0.0v 1859.495n 0.0v 1859.505n 0.0v 1869.495n 0.0v 1869.505n 0.0v 1879.495n 0.0v 1879.505n 1.8v 1889.495n 1.8v 1889.505n 1.8v 1899.495n 1.8v 1899.505n 0.0v 1909.495n 0.0v 1909.505n 0.0v 1919.495n 0.0v 1919.505n 0.0v 1929.495n 0.0v 1929.505n 1.8v 1939.495n 1.8v 1939.505n 1.8v 1949.495n 1.8v 1949.505n 1.8v 1959.495n 1.8v 1959.505n 1.8v 1969.495n 1.8v 1969.505n 1.8v 1979.495n 1.8v 1979.505n 0.0v 1989.495n 0.0v 1989.505n 0.0v 1999.495n 0.0v 1999.505n 0.0v 2009.495n 0.0v 2009.505n 1.8v 2019.495n 1.8v 2019.505n 1.8v 2029.495n 1.8v 2029.505n 1.8v 2039.495n 1.8v 2039.505n 1.8v 2049.495n 1.8v 2049.505n 1.8v )
* (time, data): [(0, 0), (10, 0), (20, 0), (30, 1), (40, 1), (50, 1), (60, 0), (70, 0), (80, 0), (90, 0), (100, 0), (110, 0), (120, 1), (130, 1), (140, 1), (150, 1), (160, 1), (170, 1), (180, 1), (190, 1), (200, 1), (210, 1), (220, 1), (230, 1), (240, 1), (250, 0), (260, 0), (270, 0), (280, 0), (290, 0), (300, 0), (310, 0), (320, 0), (330, 0), (340, 0), (350, 0), (360, 1), (370, 1), (380, 0), (390, 0), (400, 0), (410, 1), (420, 1), (430, 1), (440, 1), (450, 1), (460, 1), (470, 1), (480, 1), (490, 0), (500, 0), (510, 1), (520, 1), (530, 1), (540, 0), (550, 1), (560, 1), (570, 1), (580, 0), (590, 0), (600, 0), (610, 0), (620, 0), (630, 1), (640, 1), (650, 1), (660, 1), (670, 1), (680, 1), (690, 1), (700, 0), (710, 0), (720, 0), (730, 0), (740, 0), (750, 0), (760, 1), (770, 1), (780, 0), (790, 0), (800, 0), (810, 0), (820, 0), (830, 0), (840, 1), (850, 1), (860, 1), (870, 1), (880, 1), (890, 1), (900, 1), (910, 1), (920, 1), (930, 1), (940, 1), (950, 1), (960, 1), (970, 1), (980, 0), (990, 0), (1000, 1), (1010, 1), (1020, 1), (1030, 1), (1040, 1), (1050, 1), (1060, 1), (1070, 1), (1080, 1), (1090, 1), (1100, 1), (1110, 1), (1120, 0), (1130, 0), (1140, 0), (1150, 0), (1160, 1), (1170, 1), (1180, 1), (1190, 1), (1200, 0), (1210, 0), (1220, 0), (1230, 1), (1240, 0), (1250, 1), (1260, 1), (1270, 0), (1280, 0), (1290, 0), (1300, 0), (1310, 0), (1320, 0), (1330, 0), (1340, 1), (1350, 0), (1360, 0), (1370, 0), (1380, 0), (1390, 0), (1400, 0), (1410, 0), (1420, 0), (1430, 0), (1440, 0), (1450, 0), (1460, 1), (1470, 1), (1480, 1), (1490, 1), (1500, 1), (1510, 1), (1520, 1), (1530, 1), (1540, 1), (1550, 0), (1560, 1), (1570, 1), (1580, 1), (1590, 0), (1600, 0), (1610, 0), (1620, 0), (1630, 0), (1640, 1), (1650, 1), (1660, 1), (1670, 1), (1680, 1), (1690, 1), (1700, 1), (1710, 1), (1720, 1), (1730, 1), (1740, 1), (1750, 1), (1760, 1), (1770, 1), (1780, 1), (1790, 1), (1800, 1), (1810, 0), (1820, 0), (1830, 0), (1840, 0), (1850, 0), (1860, 0), (1870, 0), (1880, 0), (1890, 0), (1900, 0), (1910, 0), (1920, 0), (1930, 1), (1940, 1), (1950, 1), (1960, 1), (1970, 1), (1980, 0), (1990, 0), (2000, 0), (2010, 1), (2020, 1), (2030, 1), (2040, 1), (2050, 1)]
Vdin0_27  din0_27  0 PWL (0n 0.0v 9.495n 0.0v 9.505n 0.0v 19.495n 0.0v 19.505n 0.0v 29.495n 0.0v 29.505n 1.8v 39.495n 1.8v 39.505n 1.8v 49.495n 1.8v 49.505n 1.8v 59.495n 1.8v 59.505n 0.0v 69.495n 0.0v 69.505n 0.0v 79.495n 0.0v 79.505n 0.0v 89.495n 0.0v 89.505n 0.0v 99.495n 0.0v 99.505n 0.0v 109.495n 0.0v 109.505n 0.0v 119.495n 0.0v 119.505n 1.8v 129.495n 1.8v 129.505n 1.8v 139.495n 1.8v 139.505n 1.8v 149.495n 1.8v 149.505n 1.8v 159.495n 1.8v 159.505n 1.8v 169.495n 1.8v 169.505n 1.8v 179.495n 1.8v 179.505n 1.8v 189.495n 1.8v 189.505n 1.8v 199.495n 1.8v 199.505n 1.8v 209.495n 1.8v 209.505n 1.8v 219.495n 1.8v 219.505n 1.8v 229.495n 1.8v 229.505n 1.8v 239.495n 1.8v 239.505n 1.8v 249.495n 1.8v 249.505n 0.0v 259.495n 0.0v 259.505n 0.0v 269.495n 0.0v 269.505n 0.0v 279.495n 0.0v 279.505n 0.0v 289.495n 0.0v 289.505n 0.0v 299.495n 0.0v 299.505n 0.0v 309.495n 0.0v 309.505n 0.0v 319.495n 0.0v 319.505n 0.0v 329.495n 0.0v 329.505n 0.0v 339.495n 0.0v 339.505n 0.0v 349.495n 0.0v 349.505n 0.0v 359.495n 0.0v 359.505n 1.8v 369.495n 1.8v 369.505n 1.8v 379.495n 1.8v 379.505n 0.0v 389.495n 0.0v 389.505n 0.0v 399.495n 0.0v 399.505n 0.0v 409.495n 0.0v 409.505n 1.8v 419.495n 1.8v 419.505n 1.8v 429.495n 1.8v 429.505n 1.8v 439.495n 1.8v 439.505n 1.8v 449.495n 1.8v 449.505n 1.8v 459.495n 1.8v 459.505n 1.8v 469.495n 1.8v 469.505n 1.8v 479.495n 1.8v 479.505n 1.8v 489.495n 1.8v 489.505n 0.0v 499.495n 0.0v 499.505n 0.0v 509.495n 0.0v 509.505n 1.8v 519.495n 1.8v 519.505n 1.8v 529.495n 1.8v 529.505n 1.8v 539.495n 1.8v 539.505n 0.0v 549.495n 0.0v 549.505n 1.8v 559.495n 1.8v 559.505n 1.8v 569.495n 1.8v 569.505n 1.8v 579.495n 1.8v 579.505n 0.0v 589.495n 0.0v 589.505n 0.0v 599.495n 0.0v 599.505n 0.0v 609.495n 0.0v 609.505n 0.0v 619.495n 0.0v 619.505n 0.0v 629.495n 0.0v 629.505n 1.8v 639.495n 1.8v 639.505n 1.8v 649.495n 1.8v 649.505n 1.8v 659.495n 1.8v 659.505n 1.8v 669.495n 1.8v 669.505n 1.8v 679.495n 1.8v 679.505n 1.8v 689.495n 1.8v 689.505n 1.8v 699.495n 1.8v 699.505n 0.0v 709.495n 0.0v 709.505n 0.0v 719.495n 0.0v 719.505n 0.0v 729.495n 0.0v 729.505n 0.0v 739.495n 0.0v 739.505n 0.0v 749.495n 0.0v 749.505n 0.0v 759.495n 0.0v 759.505n 1.8v 769.495n 1.8v 769.505n 1.8v 779.495n 1.8v 779.505n 0.0v 789.495n 0.0v 789.505n 0.0v 799.495n 0.0v 799.505n 0.0v 809.495n 0.0v 809.505n 0.0v 819.495n 0.0v 819.505n 0.0v 829.495n 0.0v 829.505n 0.0v 839.495n 0.0v 839.505n 1.8v 849.495n 1.8v 849.505n 1.8v 859.495n 1.8v 859.505n 1.8v 869.495n 1.8v 869.505n 1.8v 879.495n 1.8v 879.505n 1.8v 889.495n 1.8v 889.505n 1.8v 899.495n 1.8v 899.505n 1.8v 909.495n 1.8v 909.505n 1.8v 919.495n 1.8v 919.505n 1.8v 929.495n 1.8v 929.505n 1.8v 939.495n 1.8v 939.505n 1.8v 949.495n 1.8v 949.505n 1.8v 959.495n 1.8v 959.505n 1.8v 969.495n 1.8v 969.505n 1.8v 979.495n 1.8v 979.505n 0.0v 989.495n 0.0v 989.505n 0.0v 999.495n 0.0v 999.505n 1.8v 1009.495n 1.8v 1009.505n 1.8v 1019.495n 1.8v 1019.505n 1.8v 1029.495n 1.8v 1029.505n 1.8v 1039.495n 1.8v 1039.505n 1.8v 1049.495n 1.8v 1049.505n 1.8v 1059.495n 1.8v 1059.505n 1.8v 1069.495n 1.8v 1069.505n 1.8v 1079.495n 1.8v 1079.505n 1.8v 1089.495n 1.8v 1089.505n 1.8v 1099.495n 1.8v 1099.505n 1.8v 1109.495n 1.8v 1109.505n 1.8v 1119.495n 1.8v 1119.505n 0.0v 1129.495n 0.0v 1129.505n 0.0v 1139.495n 0.0v 1139.505n 0.0v 1149.495n 0.0v 1149.505n 0.0v 1159.495n 0.0v 1159.505n 1.8v 1169.495n 1.8v 1169.505n 1.8v 1179.495n 1.8v 1179.505n 1.8v 1189.495n 1.8v 1189.505n 1.8v 1199.495n 1.8v 1199.505n 0.0v 1209.495n 0.0v 1209.505n 0.0v 1219.495n 0.0v 1219.505n 0.0v 1229.495n 0.0v 1229.505n 1.8v 1239.495n 1.8v 1239.505n 0.0v 1249.495n 0.0v 1249.505n 1.8v 1259.495n 1.8v 1259.505n 1.8v 1269.495n 1.8v 1269.505n 0.0v 1279.495n 0.0v 1279.505n 0.0v 1289.495n 0.0v 1289.505n 0.0v 1299.495n 0.0v 1299.505n 0.0v 1309.495n 0.0v 1309.505n 0.0v 1319.495n 0.0v 1319.505n 0.0v 1329.495n 0.0v 1329.505n 0.0v 1339.495n 0.0v 1339.505n 1.8v 1349.495n 1.8v 1349.505n 0.0v 1359.495n 0.0v 1359.505n 0.0v 1369.495n 0.0v 1369.505n 0.0v 1379.495n 0.0v 1379.505n 0.0v 1389.495n 0.0v 1389.505n 0.0v 1399.495n 0.0v 1399.505n 0.0v 1409.495n 0.0v 1409.505n 0.0v 1419.495n 0.0v 1419.505n 0.0v 1429.495n 0.0v 1429.505n 0.0v 1439.495n 0.0v 1439.505n 0.0v 1449.495n 0.0v 1449.505n 0.0v 1459.495n 0.0v 1459.505n 1.8v 1469.495n 1.8v 1469.505n 1.8v 1479.495n 1.8v 1479.505n 1.8v 1489.495n 1.8v 1489.505n 1.8v 1499.495n 1.8v 1499.505n 1.8v 1509.495n 1.8v 1509.505n 1.8v 1519.495n 1.8v 1519.505n 1.8v 1529.495n 1.8v 1529.505n 1.8v 1539.495n 1.8v 1539.505n 1.8v 1549.495n 1.8v 1549.505n 0.0v 1559.495n 0.0v 1559.505n 1.8v 1569.495n 1.8v 1569.505n 1.8v 1579.495n 1.8v 1579.505n 1.8v 1589.495n 1.8v 1589.505n 0.0v 1599.495n 0.0v 1599.505n 0.0v 1609.495n 0.0v 1609.505n 0.0v 1619.495n 0.0v 1619.505n 0.0v 1629.495n 0.0v 1629.505n 0.0v 1639.495n 0.0v 1639.505n 1.8v 1649.495n 1.8v 1649.505n 1.8v 1659.495n 1.8v 1659.505n 1.8v 1669.495n 1.8v 1669.505n 1.8v 1679.495n 1.8v 1679.505n 1.8v 1689.495n 1.8v 1689.505n 1.8v 1699.495n 1.8v 1699.505n 1.8v 1709.495n 1.8v 1709.505n 1.8v 1719.495n 1.8v 1719.505n 1.8v 1729.495n 1.8v 1729.505n 1.8v 1739.495n 1.8v 1739.505n 1.8v 1749.495n 1.8v 1749.505n 1.8v 1759.495n 1.8v 1759.505n 1.8v 1769.495n 1.8v 1769.505n 1.8v 1779.495n 1.8v 1779.505n 1.8v 1789.495n 1.8v 1789.505n 1.8v 1799.495n 1.8v 1799.505n 1.8v 1809.495n 1.8v 1809.505n 0.0v 1819.495n 0.0v 1819.505n 0.0v 1829.495n 0.0v 1829.505n 0.0v 1839.495n 0.0v 1839.505n 0.0v 1849.495n 0.0v 1849.505n 0.0v 1859.495n 0.0v 1859.505n 0.0v 1869.495n 0.0v 1869.505n 0.0v 1879.495n 0.0v 1879.505n 0.0v 1889.495n 0.0v 1889.505n 0.0v 1899.495n 0.0v 1899.505n 0.0v 1909.495n 0.0v 1909.505n 0.0v 1919.495n 0.0v 1919.505n 0.0v 1929.495n 0.0v 1929.505n 1.8v 1939.495n 1.8v 1939.505n 1.8v 1949.495n 1.8v 1949.505n 1.8v 1959.495n 1.8v 1959.505n 1.8v 1969.495n 1.8v 1969.505n 1.8v 1979.495n 1.8v 1979.505n 0.0v 1989.495n 0.0v 1989.505n 0.0v 1999.495n 0.0v 1999.505n 0.0v 2009.495n 0.0v 2009.505n 1.8v 2019.495n 1.8v 2019.505n 1.8v 2029.495n 1.8v 2029.505n 1.8v 2039.495n 1.8v 2039.505n 1.8v 2049.495n 1.8v 2049.505n 1.8v )
* (time, data): [(0, 0), (10, 0), (20, 0), (30, 0), (40, 0), (50, 0), (60, 1), (70, 1), (80, 1), (90, 1), (100, 1), (110, 1), (120, 1), (130, 1), (140, 1), (150, 1), (160, 1), (170, 1), (180, 1), (190, 1), (200, 1), (210, 1), (220, 0), (230, 0), (240, 0), (250, 0), (260, 0), (270, 0), (280, 0), (290, 0), (300, 0), (310, 0), (320, 0), (330, 0), (340, 0), (350, 0), (360, 1), (370, 1), (380, 1), (390, 1), (400, 1), (410, 1), (420, 0), (430, 0), (440, 0), (450, 0), (460, 0), (470, 0), (480, 0), (490, 1), (500, 1), (510, 0), (520, 0), (530, 1), (540, 0), (550, 0), (560, 0), (570, 0), (580, 0), (590, 1), (600, 1), (610, 1), (620, 1), (630, 1), (640, 1), (650, 1), (660, 0), (670, 0), (680, 0), (690, 0), (700, 0), (710, 0), (720, 0), (730, 0), (740, 0), (750, 0), (760, 1), (770, 1), (780, 1), (790, 1), (800, 0), (810, 0), (820, 0), (830, 0), (840, 1), (850, 1), (860, 1), (870, 0), (880, 0), (890, 0), (900, 0), (910, 0), (920, 0), (930, 0), (940, 0), (950, 0), (960, 0), (970, 1), (980, 0), (990, 0), (1000, 0), (1010, 0), (1020, 1), (1030, 1), (1040, 1), (1050, 1), (1060, 1), (1070, 1), (1080, 1), (1090, 1), (1100, 1), (1110, 1), (1120, 0), (1130, 0), (1140, 0), (1150, 0), (1160, 0), (1170, 1), (1180, 1), (1190, 1), (1200, 1), (1210, 1), (1220, 1), (1230, 0), (1240, 1), (1250, 1), (1260, 1), (1270, 0), (1280, 0), (1290, 0), (1300, 0), (1310, 0), (1320, 1), (1330, 1), (1340, 0), (1350, 0), (1360, 1), (1370, 0), (1380, 0), (1390, 0), (1400, 0), (1410, 0), (1420, 0), (1430, 0), (1440, 1), (1450, 1), (1460, 0), (1470, 0), (1480, 0), (1490, 0), (1500, 0), (1510, 0), (1520, 0), (1530, 0), (1540, 0), (1550, 0), (1560, 0), (1570, 0), (1580, 0), (1590, 1), (1600, 1), (1610, 1), (1620, 1), (1630, 1), (1640, 1), (1650, 1), (1660, 1), (1670, 1), (1680, 1), (1690, 1), (1700, 1), (1710, 1), (1720, 1), (1730, 1), (1740, 1), (1750, 1), (1760, 1), (1770, 1), (1780, 1), (1790, 0), (1800, 0), (1810, 0), (1820, 0), (1830, 0), (1840, 0), (1850, 0), (1860, 0), (1870, 0), (1880, 1), (1890, 1), (1900, 0), (1910, 0), (1920, 0), (1930, 1), (1940, 1), (1950, 1), (1960, 1), (1970, 1), (1980, 1), (1990, 1), (2000, 1), (2010, 1), (2020, 1), (2030, 1), (2040, 1), (2050, 1)]
Vdin0_28  din0_28  0 PWL (0n 0.0v 9.495n 0.0v 9.505n 0.0v 19.495n 0.0v 19.505n 0.0v 29.495n 0.0v 29.505n 0.0v 39.495n 0.0v 39.505n 0.0v 49.495n 0.0v 49.505n 0.0v 59.495n 0.0v 59.505n 1.8v 69.495n 1.8v 69.505n 1.8v 79.495n 1.8v 79.505n 1.8v 89.495n 1.8v 89.505n 1.8v 99.495n 1.8v 99.505n 1.8v 109.495n 1.8v 109.505n 1.8v 119.495n 1.8v 119.505n 1.8v 129.495n 1.8v 129.505n 1.8v 139.495n 1.8v 139.505n 1.8v 149.495n 1.8v 149.505n 1.8v 159.495n 1.8v 159.505n 1.8v 169.495n 1.8v 169.505n 1.8v 179.495n 1.8v 179.505n 1.8v 189.495n 1.8v 189.505n 1.8v 199.495n 1.8v 199.505n 1.8v 209.495n 1.8v 209.505n 1.8v 219.495n 1.8v 219.505n 0.0v 229.495n 0.0v 229.505n 0.0v 239.495n 0.0v 239.505n 0.0v 249.495n 0.0v 249.505n 0.0v 259.495n 0.0v 259.505n 0.0v 269.495n 0.0v 269.505n 0.0v 279.495n 0.0v 279.505n 0.0v 289.495n 0.0v 289.505n 0.0v 299.495n 0.0v 299.505n 0.0v 309.495n 0.0v 309.505n 0.0v 319.495n 0.0v 319.505n 0.0v 329.495n 0.0v 329.505n 0.0v 339.495n 0.0v 339.505n 0.0v 349.495n 0.0v 349.505n 0.0v 359.495n 0.0v 359.505n 1.8v 369.495n 1.8v 369.505n 1.8v 379.495n 1.8v 379.505n 1.8v 389.495n 1.8v 389.505n 1.8v 399.495n 1.8v 399.505n 1.8v 409.495n 1.8v 409.505n 1.8v 419.495n 1.8v 419.505n 0.0v 429.495n 0.0v 429.505n 0.0v 439.495n 0.0v 439.505n 0.0v 449.495n 0.0v 449.505n 0.0v 459.495n 0.0v 459.505n 0.0v 469.495n 0.0v 469.505n 0.0v 479.495n 0.0v 479.505n 0.0v 489.495n 0.0v 489.505n 1.8v 499.495n 1.8v 499.505n 1.8v 509.495n 1.8v 509.505n 0.0v 519.495n 0.0v 519.505n 0.0v 529.495n 0.0v 529.505n 1.8v 539.495n 1.8v 539.505n 0.0v 549.495n 0.0v 549.505n 0.0v 559.495n 0.0v 559.505n 0.0v 569.495n 0.0v 569.505n 0.0v 579.495n 0.0v 579.505n 0.0v 589.495n 0.0v 589.505n 1.8v 599.495n 1.8v 599.505n 1.8v 609.495n 1.8v 609.505n 1.8v 619.495n 1.8v 619.505n 1.8v 629.495n 1.8v 629.505n 1.8v 639.495n 1.8v 639.505n 1.8v 649.495n 1.8v 649.505n 1.8v 659.495n 1.8v 659.505n 0.0v 669.495n 0.0v 669.505n 0.0v 679.495n 0.0v 679.505n 0.0v 689.495n 0.0v 689.505n 0.0v 699.495n 0.0v 699.505n 0.0v 709.495n 0.0v 709.505n 0.0v 719.495n 0.0v 719.505n 0.0v 729.495n 0.0v 729.505n 0.0v 739.495n 0.0v 739.505n 0.0v 749.495n 0.0v 749.505n 0.0v 759.495n 0.0v 759.505n 1.8v 769.495n 1.8v 769.505n 1.8v 779.495n 1.8v 779.505n 1.8v 789.495n 1.8v 789.505n 1.8v 799.495n 1.8v 799.505n 0.0v 809.495n 0.0v 809.505n 0.0v 819.495n 0.0v 819.505n 0.0v 829.495n 0.0v 829.505n 0.0v 839.495n 0.0v 839.505n 1.8v 849.495n 1.8v 849.505n 1.8v 859.495n 1.8v 859.505n 1.8v 869.495n 1.8v 869.505n 0.0v 879.495n 0.0v 879.505n 0.0v 889.495n 0.0v 889.505n 0.0v 899.495n 0.0v 899.505n 0.0v 909.495n 0.0v 909.505n 0.0v 919.495n 0.0v 919.505n 0.0v 929.495n 0.0v 929.505n 0.0v 939.495n 0.0v 939.505n 0.0v 949.495n 0.0v 949.505n 0.0v 959.495n 0.0v 959.505n 0.0v 969.495n 0.0v 969.505n 1.8v 979.495n 1.8v 979.505n 0.0v 989.495n 0.0v 989.505n 0.0v 999.495n 0.0v 999.505n 0.0v 1009.495n 0.0v 1009.505n 0.0v 1019.495n 0.0v 1019.505n 1.8v 1029.495n 1.8v 1029.505n 1.8v 1039.495n 1.8v 1039.505n 1.8v 1049.495n 1.8v 1049.505n 1.8v 1059.495n 1.8v 1059.505n 1.8v 1069.495n 1.8v 1069.505n 1.8v 1079.495n 1.8v 1079.505n 1.8v 1089.495n 1.8v 1089.505n 1.8v 1099.495n 1.8v 1099.505n 1.8v 1109.495n 1.8v 1109.505n 1.8v 1119.495n 1.8v 1119.505n 0.0v 1129.495n 0.0v 1129.505n 0.0v 1139.495n 0.0v 1139.505n 0.0v 1149.495n 0.0v 1149.505n 0.0v 1159.495n 0.0v 1159.505n 0.0v 1169.495n 0.0v 1169.505n 1.8v 1179.495n 1.8v 1179.505n 1.8v 1189.495n 1.8v 1189.505n 1.8v 1199.495n 1.8v 1199.505n 1.8v 1209.495n 1.8v 1209.505n 1.8v 1219.495n 1.8v 1219.505n 1.8v 1229.495n 1.8v 1229.505n 0.0v 1239.495n 0.0v 1239.505n 1.8v 1249.495n 1.8v 1249.505n 1.8v 1259.495n 1.8v 1259.505n 1.8v 1269.495n 1.8v 1269.505n 0.0v 1279.495n 0.0v 1279.505n 0.0v 1289.495n 0.0v 1289.505n 0.0v 1299.495n 0.0v 1299.505n 0.0v 1309.495n 0.0v 1309.505n 0.0v 1319.495n 0.0v 1319.505n 1.8v 1329.495n 1.8v 1329.505n 1.8v 1339.495n 1.8v 1339.505n 0.0v 1349.495n 0.0v 1349.505n 0.0v 1359.495n 0.0v 1359.505n 1.8v 1369.495n 1.8v 1369.505n 0.0v 1379.495n 0.0v 1379.505n 0.0v 1389.495n 0.0v 1389.505n 0.0v 1399.495n 0.0v 1399.505n 0.0v 1409.495n 0.0v 1409.505n 0.0v 1419.495n 0.0v 1419.505n 0.0v 1429.495n 0.0v 1429.505n 0.0v 1439.495n 0.0v 1439.505n 1.8v 1449.495n 1.8v 1449.505n 1.8v 1459.495n 1.8v 1459.505n 0.0v 1469.495n 0.0v 1469.505n 0.0v 1479.495n 0.0v 1479.505n 0.0v 1489.495n 0.0v 1489.505n 0.0v 1499.495n 0.0v 1499.505n 0.0v 1509.495n 0.0v 1509.505n 0.0v 1519.495n 0.0v 1519.505n 0.0v 1529.495n 0.0v 1529.505n 0.0v 1539.495n 0.0v 1539.505n 0.0v 1549.495n 0.0v 1549.505n 0.0v 1559.495n 0.0v 1559.505n 0.0v 1569.495n 0.0v 1569.505n 0.0v 1579.495n 0.0v 1579.505n 0.0v 1589.495n 0.0v 1589.505n 1.8v 1599.495n 1.8v 1599.505n 1.8v 1609.495n 1.8v 1609.505n 1.8v 1619.495n 1.8v 1619.505n 1.8v 1629.495n 1.8v 1629.505n 1.8v 1639.495n 1.8v 1639.505n 1.8v 1649.495n 1.8v 1649.505n 1.8v 1659.495n 1.8v 1659.505n 1.8v 1669.495n 1.8v 1669.505n 1.8v 1679.495n 1.8v 1679.505n 1.8v 1689.495n 1.8v 1689.505n 1.8v 1699.495n 1.8v 1699.505n 1.8v 1709.495n 1.8v 1709.505n 1.8v 1719.495n 1.8v 1719.505n 1.8v 1729.495n 1.8v 1729.505n 1.8v 1739.495n 1.8v 1739.505n 1.8v 1749.495n 1.8v 1749.505n 1.8v 1759.495n 1.8v 1759.505n 1.8v 1769.495n 1.8v 1769.505n 1.8v 1779.495n 1.8v 1779.505n 1.8v 1789.495n 1.8v 1789.505n 0.0v 1799.495n 0.0v 1799.505n 0.0v 1809.495n 0.0v 1809.505n 0.0v 1819.495n 0.0v 1819.505n 0.0v 1829.495n 0.0v 1829.505n 0.0v 1839.495n 0.0v 1839.505n 0.0v 1849.495n 0.0v 1849.505n 0.0v 1859.495n 0.0v 1859.505n 0.0v 1869.495n 0.0v 1869.505n 0.0v 1879.495n 0.0v 1879.505n 1.8v 1889.495n 1.8v 1889.505n 1.8v 1899.495n 1.8v 1899.505n 0.0v 1909.495n 0.0v 1909.505n 0.0v 1919.495n 0.0v 1919.505n 0.0v 1929.495n 0.0v 1929.505n 1.8v 1939.495n 1.8v 1939.505n 1.8v 1949.495n 1.8v 1949.505n 1.8v 1959.495n 1.8v 1959.505n 1.8v 1969.495n 1.8v 1969.505n 1.8v 1979.495n 1.8v 1979.505n 1.8v 1989.495n 1.8v 1989.505n 1.8v 1999.495n 1.8v 1999.505n 1.8v 2009.495n 1.8v 2009.505n 1.8v 2019.495n 1.8v 2019.505n 1.8v 2029.495n 1.8v 2029.505n 1.8v 2039.495n 1.8v 2039.505n 1.8v 2049.495n 1.8v 2049.505n 1.8v )
* (time, data): [(0, 0), (10, 0), (20, 0), (30, 1), (40, 1), (50, 1), (60, 1), (70, 1), (80, 1), (90, 1), (100, 1), (110, 1), (120, 1), (130, 1), (140, 1), (150, 1), (160, 1), (170, 1), (180, 1), (190, 1), (200, 0), (210, 0), (220, 1), (230, 1), (240, 1), (250, 1), (260, 1), (270, 1), (280, 1), (290, 1), (300, 1), (310, 1), (320, 0), (330, 0), (340, 0), (350, 0), (360, 0), (370, 0), (380, 0), (390, 0), (400, 0), (410, 0), (420, 0), (430, 0), (440, 0), (450, 0), (460, 0), (470, 0), (480, 0), (490, 0), (500, 0), (510, 1), (520, 1), (530, 1), (540, 1), (550, 1), (560, 1), (570, 1), (580, 1), (590, 1), (600, 1), (610, 1), (620, 1), (630, 0), (640, 0), (650, 0), (660, 1), (670, 1), (680, 1), (690, 1), (700, 0), (710, 0), (720, 0), (730, 0), (740, 1), (750, 1), (760, 1), (770, 1), (780, 1), (790, 1), (800, 1), (810, 1), (820, 1), (830, 1), (840, 1), (850, 1), (860, 1), (870, 0), (880, 0), (890, 0), (900, 0), (910, 0), (920, 1), (930, 1), (940, 1), (950, 1), (960, 1), (970, 0), (980, 0), (990, 0), (1000, 1), (1010, 1), (1020, 0), (1030, 0), (1040, 0), (1050, 0), (1060, 0), (1070, 0), (1080, 0), (1090, 0), (1100, 0), (1110, 0), (1120, 1), (1130, 1), (1140, 1), (1150, 1), (1160, 0), (1170, 1), (1180, 1), (1190, 1), (1200, 0), (1210, 0), (1220, 0), (1230, 0), (1240, 0), (1250, 1), (1260, 0), (1270, 0), (1280, 0), (1290, 0), (1300, 0), (1310, 0), (1320, 1), (1330, 0), (1340, 0), (1350, 0), (1360, 0), (1370, 0), (1380, 0), (1390, 0), (1400, 0), (1410, 0), (1420, 0), (1430, 0), (1440, 0), (1450, 0), (1460, 0), (1470, 1), (1480, 1), (1490, 1), (1500, 1), (1510, 1), (1520, 1), (1530, 1), (1540, 1), (1550, 0), (1560, 0), (1570, 0), (1580, 0), (1590, 1), (1600, 1), (1610, 1), (1620, 1), (1630, 1), (1640, 0), (1650, 0), (1660, 0), (1670, 0), (1680, 0), (1690, 0), (1700, 0), (1710, 0), (1720, 0), (1730, 0), (1740, 0), (1750, 0), (1760, 0), (1770, 1), (1780, 1), (1790, 1), (1800, 1), (1810, 1), (1820, 1), (1830, 1), (1840, 1), (1850, 1), (1860, 1), (1870, 1), (1880, 0), (1890, 0), (1900, 0), (1910, 1), (1920, 1), (1930, 0), (1940, 0), (1950, 0), (1960, 0), (1970, 0), (1980, 1), (1990, 1), (2000, 1), (2010, 1), (2020, 1), (2030, 1), (2040, 1), (2050, 1)]
Vdin0_29  din0_29  0 PWL (0n 0.0v 9.495n 0.0v 9.505n 0.0v 19.495n 0.0v 19.505n 0.0v 29.495n 0.0v 29.505n 1.8v 39.495n 1.8v 39.505n 1.8v 49.495n 1.8v 49.505n 1.8v 59.495n 1.8v 59.505n 1.8v 69.495n 1.8v 69.505n 1.8v 79.495n 1.8v 79.505n 1.8v 89.495n 1.8v 89.505n 1.8v 99.495n 1.8v 99.505n 1.8v 109.495n 1.8v 109.505n 1.8v 119.495n 1.8v 119.505n 1.8v 129.495n 1.8v 129.505n 1.8v 139.495n 1.8v 139.505n 1.8v 149.495n 1.8v 149.505n 1.8v 159.495n 1.8v 159.505n 1.8v 169.495n 1.8v 169.505n 1.8v 179.495n 1.8v 179.505n 1.8v 189.495n 1.8v 189.505n 1.8v 199.495n 1.8v 199.505n 0.0v 209.495n 0.0v 209.505n 0.0v 219.495n 0.0v 219.505n 1.8v 229.495n 1.8v 229.505n 1.8v 239.495n 1.8v 239.505n 1.8v 249.495n 1.8v 249.505n 1.8v 259.495n 1.8v 259.505n 1.8v 269.495n 1.8v 269.505n 1.8v 279.495n 1.8v 279.505n 1.8v 289.495n 1.8v 289.505n 1.8v 299.495n 1.8v 299.505n 1.8v 309.495n 1.8v 309.505n 1.8v 319.495n 1.8v 319.505n 0.0v 329.495n 0.0v 329.505n 0.0v 339.495n 0.0v 339.505n 0.0v 349.495n 0.0v 349.505n 0.0v 359.495n 0.0v 359.505n 0.0v 369.495n 0.0v 369.505n 0.0v 379.495n 0.0v 379.505n 0.0v 389.495n 0.0v 389.505n 0.0v 399.495n 0.0v 399.505n 0.0v 409.495n 0.0v 409.505n 0.0v 419.495n 0.0v 419.505n 0.0v 429.495n 0.0v 429.505n 0.0v 439.495n 0.0v 439.505n 0.0v 449.495n 0.0v 449.505n 0.0v 459.495n 0.0v 459.505n 0.0v 469.495n 0.0v 469.505n 0.0v 479.495n 0.0v 479.505n 0.0v 489.495n 0.0v 489.505n 0.0v 499.495n 0.0v 499.505n 0.0v 509.495n 0.0v 509.505n 1.8v 519.495n 1.8v 519.505n 1.8v 529.495n 1.8v 529.505n 1.8v 539.495n 1.8v 539.505n 1.8v 549.495n 1.8v 549.505n 1.8v 559.495n 1.8v 559.505n 1.8v 569.495n 1.8v 569.505n 1.8v 579.495n 1.8v 579.505n 1.8v 589.495n 1.8v 589.505n 1.8v 599.495n 1.8v 599.505n 1.8v 609.495n 1.8v 609.505n 1.8v 619.495n 1.8v 619.505n 1.8v 629.495n 1.8v 629.505n 0.0v 639.495n 0.0v 639.505n 0.0v 649.495n 0.0v 649.505n 0.0v 659.495n 0.0v 659.505n 1.8v 669.495n 1.8v 669.505n 1.8v 679.495n 1.8v 679.505n 1.8v 689.495n 1.8v 689.505n 1.8v 699.495n 1.8v 699.505n 0.0v 709.495n 0.0v 709.505n 0.0v 719.495n 0.0v 719.505n 0.0v 729.495n 0.0v 729.505n 0.0v 739.495n 0.0v 739.505n 1.8v 749.495n 1.8v 749.505n 1.8v 759.495n 1.8v 759.505n 1.8v 769.495n 1.8v 769.505n 1.8v 779.495n 1.8v 779.505n 1.8v 789.495n 1.8v 789.505n 1.8v 799.495n 1.8v 799.505n 1.8v 809.495n 1.8v 809.505n 1.8v 819.495n 1.8v 819.505n 1.8v 829.495n 1.8v 829.505n 1.8v 839.495n 1.8v 839.505n 1.8v 849.495n 1.8v 849.505n 1.8v 859.495n 1.8v 859.505n 1.8v 869.495n 1.8v 869.505n 0.0v 879.495n 0.0v 879.505n 0.0v 889.495n 0.0v 889.505n 0.0v 899.495n 0.0v 899.505n 0.0v 909.495n 0.0v 909.505n 0.0v 919.495n 0.0v 919.505n 1.8v 929.495n 1.8v 929.505n 1.8v 939.495n 1.8v 939.505n 1.8v 949.495n 1.8v 949.505n 1.8v 959.495n 1.8v 959.505n 1.8v 969.495n 1.8v 969.505n 0.0v 979.495n 0.0v 979.505n 0.0v 989.495n 0.0v 989.505n 0.0v 999.495n 0.0v 999.505n 1.8v 1009.495n 1.8v 1009.505n 1.8v 1019.495n 1.8v 1019.505n 0.0v 1029.495n 0.0v 1029.505n 0.0v 1039.495n 0.0v 1039.505n 0.0v 1049.495n 0.0v 1049.505n 0.0v 1059.495n 0.0v 1059.505n 0.0v 1069.495n 0.0v 1069.505n 0.0v 1079.495n 0.0v 1079.505n 0.0v 1089.495n 0.0v 1089.505n 0.0v 1099.495n 0.0v 1099.505n 0.0v 1109.495n 0.0v 1109.505n 0.0v 1119.495n 0.0v 1119.505n 1.8v 1129.495n 1.8v 1129.505n 1.8v 1139.495n 1.8v 1139.505n 1.8v 1149.495n 1.8v 1149.505n 1.8v 1159.495n 1.8v 1159.505n 0.0v 1169.495n 0.0v 1169.505n 1.8v 1179.495n 1.8v 1179.505n 1.8v 1189.495n 1.8v 1189.505n 1.8v 1199.495n 1.8v 1199.505n 0.0v 1209.495n 0.0v 1209.505n 0.0v 1219.495n 0.0v 1219.505n 0.0v 1229.495n 0.0v 1229.505n 0.0v 1239.495n 0.0v 1239.505n 0.0v 1249.495n 0.0v 1249.505n 1.8v 1259.495n 1.8v 1259.505n 0.0v 1269.495n 0.0v 1269.505n 0.0v 1279.495n 0.0v 1279.505n 0.0v 1289.495n 0.0v 1289.505n 0.0v 1299.495n 0.0v 1299.505n 0.0v 1309.495n 0.0v 1309.505n 0.0v 1319.495n 0.0v 1319.505n 1.8v 1329.495n 1.8v 1329.505n 0.0v 1339.495n 0.0v 1339.505n 0.0v 1349.495n 0.0v 1349.505n 0.0v 1359.495n 0.0v 1359.505n 0.0v 1369.495n 0.0v 1369.505n 0.0v 1379.495n 0.0v 1379.505n 0.0v 1389.495n 0.0v 1389.505n 0.0v 1399.495n 0.0v 1399.505n 0.0v 1409.495n 0.0v 1409.505n 0.0v 1419.495n 0.0v 1419.505n 0.0v 1429.495n 0.0v 1429.505n 0.0v 1439.495n 0.0v 1439.505n 0.0v 1449.495n 0.0v 1449.505n 0.0v 1459.495n 0.0v 1459.505n 0.0v 1469.495n 0.0v 1469.505n 1.8v 1479.495n 1.8v 1479.505n 1.8v 1489.495n 1.8v 1489.505n 1.8v 1499.495n 1.8v 1499.505n 1.8v 1509.495n 1.8v 1509.505n 1.8v 1519.495n 1.8v 1519.505n 1.8v 1529.495n 1.8v 1529.505n 1.8v 1539.495n 1.8v 1539.505n 1.8v 1549.495n 1.8v 1549.505n 0.0v 1559.495n 0.0v 1559.505n 0.0v 1569.495n 0.0v 1569.505n 0.0v 1579.495n 0.0v 1579.505n 0.0v 1589.495n 0.0v 1589.505n 1.8v 1599.495n 1.8v 1599.505n 1.8v 1609.495n 1.8v 1609.505n 1.8v 1619.495n 1.8v 1619.505n 1.8v 1629.495n 1.8v 1629.505n 1.8v 1639.495n 1.8v 1639.505n 0.0v 1649.495n 0.0v 1649.505n 0.0v 1659.495n 0.0v 1659.505n 0.0v 1669.495n 0.0v 1669.505n 0.0v 1679.495n 0.0v 1679.505n 0.0v 1689.495n 0.0v 1689.505n 0.0v 1699.495n 0.0v 1699.505n 0.0v 1709.495n 0.0v 1709.505n 0.0v 1719.495n 0.0v 1719.505n 0.0v 1729.495n 0.0v 1729.505n 0.0v 1739.495n 0.0v 1739.505n 0.0v 1749.495n 0.0v 1749.505n 0.0v 1759.495n 0.0v 1759.505n 0.0v 1769.495n 0.0v 1769.505n 1.8v 1779.495n 1.8v 1779.505n 1.8v 1789.495n 1.8v 1789.505n 1.8v 1799.495n 1.8v 1799.505n 1.8v 1809.495n 1.8v 1809.505n 1.8v 1819.495n 1.8v 1819.505n 1.8v 1829.495n 1.8v 1829.505n 1.8v 1839.495n 1.8v 1839.505n 1.8v 1849.495n 1.8v 1849.505n 1.8v 1859.495n 1.8v 1859.505n 1.8v 1869.495n 1.8v 1869.505n 1.8v 1879.495n 1.8v 1879.505n 0.0v 1889.495n 0.0v 1889.505n 0.0v 1899.495n 0.0v 1899.505n 0.0v 1909.495n 0.0v 1909.505n 1.8v 1919.495n 1.8v 1919.505n 1.8v 1929.495n 1.8v 1929.505n 0.0v 1939.495n 0.0v 1939.505n 0.0v 1949.495n 0.0v 1949.505n 0.0v 1959.495n 0.0v 1959.505n 0.0v 1969.495n 0.0v 1969.505n 0.0v 1979.495n 0.0v 1979.505n 1.8v 1989.495n 1.8v 1989.505n 1.8v 1999.495n 1.8v 1999.505n 1.8v 2009.495n 1.8v 2009.505n 1.8v 2019.495n 1.8v 2019.505n 1.8v 2029.495n 1.8v 2029.505n 1.8v 2039.495n 1.8v 2039.505n 1.8v 2049.495n 1.8v 2049.505n 1.8v )
* (time, data): [(0, 0), (10, 0), (20, 0), (30, 0), (40, 0), (50, 0), (60, 0), (70, 0), (80, 0), (90, 1), (100, 1), (110, 1), (120, 1), (130, 1), (140, 1), (150, 1), (160, 1), (170, 1), (180, 1), (190, 1), (200, 1), (210, 1), (220, 0), (230, 0), (240, 0), (250, 1), (260, 1), (270, 1), (280, 1), (290, 1), (300, 1), (310, 1), (320, 1), (330, 1), (340, 1), (350, 1), (360, 1), (370, 1), (380, 0), (390, 0), (400, 0), (410, 1), (420, 1), (430, 1), (440, 0), (450, 0), (460, 0), (470, 0), (480, 0), (490, 0), (500, 0), (510, 0), (520, 0), (530, 0), (540, 0), (550, 1), (560, 1), (570, 1), (580, 1), (590, 1), (600, 1), (610, 1), (620, 1), (630, 0), (640, 0), (650, 0), (660, 1), (670, 0), (680, 0), (690, 0), (700, 1), (710, 1), (720, 1), (730, 0), (740, 0), (750, 0), (760, 1), (770, 0), (780, 0), (790, 0), (800, 0), (810, 0), (820, 0), (830, 0), (840, 1), (850, 1), (860, 1), (870, 1), (880, 1), (890, 1), (900, 1), (910, 1), (920, 0), (930, 0), (940, 0), (950, 0), (960, 0), (970, 1), (980, 0), (990, 0), (1000, 1), (1010, 1), (1020, 0), (1030, 0), (1040, 0), (1050, 0), (1060, 0), (1070, 0), (1080, 0), (1090, 0), (1100, 0), (1110, 0), (1120, 0), (1130, 0), (1140, 1), (1150, 1), (1160, 1), (1170, 1), (1180, 1), (1190, 1), (1200, 0), (1210, 0), (1220, 0), (1230, 1), (1240, 0), (1250, 1), (1260, 1), (1270, 0), (1280, 0), (1290, 0), (1300, 0), (1310, 0), (1320, 0), (1330, 0), (1340, 1), (1350, 0), (1360, 1), (1370, 1), (1380, 1), (1390, 1), (1400, 1), (1410, 1), (1420, 1), (1430, 1), (1440, 1), (1450, 1), (1460, 0), (1470, 1), (1480, 1), (1490, 1), (1500, 1), (1510, 1), (1520, 1), (1530, 1), (1540, 1), (1550, 0), (1560, 1), (1570, 1), (1580, 1), (1590, 1), (1600, 1), (1610, 1), (1620, 1), (1630, 1), (1640, 0), (1650, 0), (1660, 0), (1670, 0), (1680, 0), (1690, 0), (1700, 0), (1710, 0), (1720, 0), (1730, 0), (1740, 0), (1750, 0), (1760, 0), (1770, 0), (1780, 1), (1790, 1), (1800, 1), (1810, 1), (1820, 1), (1830, 1), (1840, 1), (1850, 1), (1860, 1), (1870, 1), (1880, 0), (1890, 0), (1900, 1), (1910, 1), (1920, 1), (1930, 0), (1940, 0), (1950, 0), (1960, 0), (1970, 0), (1980, 0), (1990, 0), (2000, 0), (2010, 0), (2020, 0), (2030, 0), (2040, 0), (2050, 0)]
Vdin0_30  din0_30  0 PWL (0n 0.0v 9.495n 0.0v 9.505n 0.0v 19.495n 0.0v 19.505n 0.0v 29.495n 0.0v 29.505n 0.0v 39.495n 0.0v 39.505n 0.0v 49.495n 0.0v 49.505n 0.0v 59.495n 0.0v 59.505n 0.0v 69.495n 0.0v 69.505n 0.0v 79.495n 0.0v 79.505n 0.0v 89.495n 0.0v 89.505n 1.8v 99.495n 1.8v 99.505n 1.8v 109.495n 1.8v 109.505n 1.8v 119.495n 1.8v 119.505n 1.8v 129.495n 1.8v 129.505n 1.8v 139.495n 1.8v 139.505n 1.8v 149.495n 1.8v 149.505n 1.8v 159.495n 1.8v 159.505n 1.8v 169.495n 1.8v 169.505n 1.8v 179.495n 1.8v 179.505n 1.8v 189.495n 1.8v 189.505n 1.8v 199.495n 1.8v 199.505n 1.8v 209.495n 1.8v 209.505n 1.8v 219.495n 1.8v 219.505n 0.0v 229.495n 0.0v 229.505n 0.0v 239.495n 0.0v 239.505n 0.0v 249.495n 0.0v 249.505n 1.8v 259.495n 1.8v 259.505n 1.8v 269.495n 1.8v 269.505n 1.8v 279.495n 1.8v 279.505n 1.8v 289.495n 1.8v 289.505n 1.8v 299.495n 1.8v 299.505n 1.8v 309.495n 1.8v 309.505n 1.8v 319.495n 1.8v 319.505n 1.8v 329.495n 1.8v 329.505n 1.8v 339.495n 1.8v 339.505n 1.8v 349.495n 1.8v 349.505n 1.8v 359.495n 1.8v 359.505n 1.8v 369.495n 1.8v 369.505n 1.8v 379.495n 1.8v 379.505n 0.0v 389.495n 0.0v 389.505n 0.0v 399.495n 0.0v 399.505n 0.0v 409.495n 0.0v 409.505n 1.8v 419.495n 1.8v 419.505n 1.8v 429.495n 1.8v 429.505n 1.8v 439.495n 1.8v 439.505n 0.0v 449.495n 0.0v 449.505n 0.0v 459.495n 0.0v 459.505n 0.0v 469.495n 0.0v 469.505n 0.0v 479.495n 0.0v 479.505n 0.0v 489.495n 0.0v 489.505n 0.0v 499.495n 0.0v 499.505n 0.0v 509.495n 0.0v 509.505n 0.0v 519.495n 0.0v 519.505n 0.0v 529.495n 0.0v 529.505n 0.0v 539.495n 0.0v 539.505n 0.0v 549.495n 0.0v 549.505n 1.8v 559.495n 1.8v 559.505n 1.8v 569.495n 1.8v 569.505n 1.8v 579.495n 1.8v 579.505n 1.8v 589.495n 1.8v 589.505n 1.8v 599.495n 1.8v 599.505n 1.8v 609.495n 1.8v 609.505n 1.8v 619.495n 1.8v 619.505n 1.8v 629.495n 1.8v 629.505n 0.0v 639.495n 0.0v 639.505n 0.0v 649.495n 0.0v 649.505n 0.0v 659.495n 0.0v 659.505n 1.8v 669.495n 1.8v 669.505n 0.0v 679.495n 0.0v 679.505n 0.0v 689.495n 0.0v 689.505n 0.0v 699.495n 0.0v 699.505n 1.8v 709.495n 1.8v 709.505n 1.8v 719.495n 1.8v 719.505n 1.8v 729.495n 1.8v 729.505n 0.0v 739.495n 0.0v 739.505n 0.0v 749.495n 0.0v 749.505n 0.0v 759.495n 0.0v 759.505n 1.8v 769.495n 1.8v 769.505n 0.0v 779.495n 0.0v 779.505n 0.0v 789.495n 0.0v 789.505n 0.0v 799.495n 0.0v 799.505n 0.0v 809.495n 0.0v 809.505n 0.0v 819.495n 0.0v 819.505n 0.0v 829.495n 0.0v 829.505n 0.0v 839.495n 0.0v 839.505n 1.8v 849.495n 1.8v 849.505n 1.8v 859.495n 1.8v 859.505n 1.8v 869.495n 1.8v 869.505n 1.8v 879.495n 1.8v 879.505n 1.8v 889.495n 1.8v 889.505n 1.8v 899.495n 1.8v 899.505n 1.8v 909.495n 1.8v 909.505n 1.8v 919.495n 1.8v 919.505n 0.0v 929.495n 0.0v 929.505n 0.0v 939.495n 0.0v 939.505n 0.0v 949.495n 0.0v 949.505n 0.0v 959.495n 0.0v 959.505n 0.0v 969.495n 0.0v 969.505n 1.8v 979.495n 1.8v 979.505n 0.0v 989.495n 0.0v 989.505n 0.0v 999.495n 0.0v 999.505n 1.8v 1009.495n 1.8v 1009.505n 1.8v 1019.495n 1.8v 1019.505n 0.0v 1029.495n 0.0v 1029.505n 0.0v 1039.495n 0.0v 1039.505n 0.0v 1049.495n 0.0v 1049.505n 0.0v 1059.495n 0.0v 1059.505n 0.0v 1069.495n 0.0v 1069.505n 0.0v 1079.495n 0.0v 1079.505n 0.0v 1089.495n 0.0v 1089.505n 0.0v 1099.495n 0.0v 1099.505n 0.0v 1109.495n 0.0v 1109.505n 0.0v 1119.495n 0.0v 1119.505n 0.0v 1129.495n 0.0v 1129.505n 0.0v 1139.495n 0.0v 1139.505n 1.8v 1149.495n 1.8v 1149.505n 1.8v 1159.495n 1.8v 1159.505n 1.8v 1169.495n 1.8v 1169.505n 1.8v 1179.495n 1.8v 1179.505n 1.8v 1189.495n 1.8v 1189.505n 1.8v 1199.495n 1.8v 1199.505n 0.0v 1209.495n 0.0v 1209.505n 0.0v 1219.495n 0.0v 1219.505n 0.0v 1229.495n 0.0v 1229.505n 1.8v 1239.495n 1.8v 1239.505n 0.0v 1249.495n 0.0v 1249.505n 1.8v 1259.495n 1.8v 1259.505n 1.8v 1269.495n 1.8v 1269.505n 0.0v 1279.495n 0.0v 1279.505n 0.0v 1289.495n 0.0v 1289.505n 0.0v 1299.495n 0.0v 1299.505n 0.0v 1309.495n 0.0v 1309.505n 0.0v 1319.495n 0.0v 1319.505n 0.0v 1329.495n 0.0v 1329.505n 0.0v 1339.495n 0.0v 1339.505n 1.8v 1349.495n 1.8v 1349.505n 0.0v 1359.495n 0.0v 1359.505n 1.8v 1369.495n 1.8v 1369.505n 1.8v 1379.495n 1.8v 1379.505n 1.8v 1389.495n 1.8v 1389.505n 1.8v 1399.495n 1.8v 1399.505n 1.8v 1409.495n 1.8v 1409.505n 1.8v 1419.495n 1.8v 1419.505n 1.8v 1429.495n 1.8v 1429.505n 1.8v 1439.495n 1.8v 1439.505n 1.8v 1449.495n 1.8v 1449.505n 1.8v 1459.495n 1.8v 1459.505n 0.0v 1469.495n 0.0v 1469.505n 1.8v 1479.495n 1.8v 1479.505n 1.8v 1489.495n 1.8v 1489.505n 1.8v 1499.495n 1.8v 1499.505n 1.8v 1509.495n 1.8v 1509.505n 1.8v 1519.495n 1.8v 1519.505n 1.8v 1529.495n 1.8v 1529.505n 1.8v 1539.495n 1.8v 1539.505n 1.8v 1549.495n 1.8v 1549.505n 0.0v 1559.495n 0.0v 1559.505n 1.8v 1569.495n 1.8v 1569.505n 1.8v 1579.495n 1.8v 1579.505n 1.8v 1589.495n 1.8v 1589.505n 1.8v 1599.495n 1.8v 1599.505n 1.8v 1609.495n 1.8v 1609.505n 1.8v 1619.495n 1.8v 1619.505n 1.8v 1629.495n 1.8v 1629.505n 1.8v 1639.495n 1.8v 1639.505n 0.0v 1649.495n 0.0v 1649.505n 0.0v 1659.495n 0.0v 1659.505n 0.0v 1669.495n 0.0v 1669.505n 0.0v 1679.495n 0.0v 1679.505n 0.0v 1689.495n 0.0v 1689.505n 0.0v 1699.495n 0.0v 1699.505n 0.0v 1709.495n 0.0v 1709.505n 0.0v 1719.495n 0.0v 1719.505n 0.0v 1729.495n 0.0v 1729.505n 0.0v 1739.495n 0.0v 1739.505n 0.0v 1749.495n 0.0v 1749.505n 0.0v 1759.495n 0.0v 1759.505n 0.0v 1769.495n 0.0v 1769.505n 0.0v 1779.495n 0.0v 1779.505n 1.8v 1789.495n 1.8v 1789.505n 1.8v 1799.495n 1.8v 1799.505n 1.8v 1809.495n 1.8v 1809.505n 1.8v 1819.495n 1.8v 1819.505n 1.8v 1829.495n 1.8v 1829.505n 1.8v 1839.495n 1.8v 1839.505n 1.8v 1849.495n 1.8v 1849.505n 1.8v 1859.495n 1.8v 1859.505n 1.8v 1869.495n 1.8v 1869.505n 1.8v 1879.495n 1.8v 1879.505n 0.0v 1889.495n 0.0v 1889.505n 0.0v 1899.495n 0.0v 1899.505n 1.8v 1909.495n 1.8v 1909.505n 1.8v 1919.495n 1.8v 1919.505n 1.8v 1929.495n 1.8v 1929.505n 0.0v 1939.495n 0.0v 1939.505n 0.0v 1949.495n 0.0v 1949.505n 0.0v 1959.495n 0.0v 1959.505n 0.0v 1969.495n 0.0v 1969.505n 0.0v 1979.495n 0.0v 1979.505n 0.0v 1989.495n 0.0v 1989.505n 0.0v 1999.495n 0.0v 1999.505n 0.0v 2009.495n 0.0v 2009.505n 0.0v 2019.495n 0.0v 2019.505n 0.0v 2029.495n 0.0v 2029.505n 0.0v 2039.495n 0.0v 2039.505n 0.0v 2049.495n 0.0v 2049.505n 0.0v )
* (time, data): [(0, 0), (10, 0), (20, 1), (30, 0), (40, 0), (50, 0), (60, 1), (70, 1), (80, 1), (90, 0), (100, 0), (110, 0), (120, 1), (130, 1), (140, 1), (150, 1), (160, 1), (170, 1), (180, 1), (190, 1), (200, 1), (210, 1), (220, 0), (230, 0), (240, 0), (250, 0), (260, 0), (270, 0), (280, 0), (290, 0), (300, 0), (310, 0), (320, 0), (330, 0), (340, 0), (350, 0), (360, 0), (370, 0), (380, 0), (390, 0), (400, 0), (410, 0), (420, 0), (430, 0), (440, 1), (450, 1), (460, 1), (470, 1), (480, 1), (490, 1), (500, 1), (510, 0), (520, 0), (530, 0), (540, 0), (550, 1), (560, 1), (570, 1), (580, 0), (590, 1), (600, 1), (610, 1), (620, 1), (630, 1), (640, 1), (650, 1), (660, 1), (670, 0), (680, 0), (690, 0), (700, 0), (710, 0), (720, 0), (730, 1), (740, 0), (750, 0), (760, 1), (770, 0), (780, 1), (790, 1), (800, 0), (810, 0), (820, 0), (830, 0), (840, 0), (850, 0), (860, 0), (870, 0), (880, 0), (890, 0), (900, 0), (910, 0), (920, 1), (930, 1), (940, 1), (950, 1), (960, 1), (970, 0), (980, 0), (990, 0), (1000, 1), (1010, 1), (1020, 0), (1030, 0), (1040, 0), (1050, 0), (1060, 0), (1070, 0), (1080, 0), (1090, 0), (1100, 0), (1110, 0), (1120, 0), (1130, 0), (1140, 0), (1150, 0), (1160, 0), (1170, 1), (1180, 1), (1190, 1), (1200, 0), (1210, 0), (1220, 0), (1230, 0), (1240, 0), (1250, 1), (1260, 1), (1270, 0), (1280, 0), (1290, 0), (1300, 0), (1310, 0), (1320, 0), (1330, 0), (1340, 0), (1350, 1), (1360, 1), (1370, 1), (1380, 1), (1390, 1), (1400, 1), (1410, 1), (1420, 1), (1430, 1), (1440, 1), (1450, 1), (1460, 1), (1470, 0), (1480, 0), (1490, 0), (1500, 0), (1510, 0), (1520, 0), (1530, 0), (1540, 0), (1550, 0), (1560, 1), (1570, 1), (1580, 1), (1590, 0), (1600, 0), (1610, 0), (1620, 0), (1630, 0), (1640, 1), (1650, 1), (1660, 1), (1670, 1), (1680, 1), (1690, 1), (1700, 1), (1710, 1), (1720, 1), (1730, 1), (1740, 1), (1750, 1), (1760, 1), (1770, 1), (1780, 1), (1790, 1), (1800, 0), (1810, 1), (1820, 1), (1830, 1), (1840, 1), (1850, 1), (1860, 1), (1870, 1), (1880, 0), (1890, 0), (1900, 0), (1910, 0), (1920, 0), (1930, 1), (1940, 1), (1950, 1), (1960, 1), (1970, 1), (1980, 0), (1990, 0), (2000, 0), (2010, 1), (2020, 1), (2030, 1), (2040, 1), (2050, 1)]
Vdin0_31  din0_31  0 PWL (0n 0.0v 9.495n 0.0v 9.505n 0.0v 19.495n 0.0v 19.505n 1.8v 29.495n 1.8v 29.505n 0.0v 39.495n 0.0v 39.505n 0.0v 49.495n 0.0v 49.505n 0.0v 59.495n 0.0v 59.505n 1.8v 69.495n 1.8v 69.505n 1.8v 79.495n 1.8v 79.505n 1.8v 89.495n 1.8v 89.505n 0.0v 99.495n 0.0v 99.505n 0.0v 109.495n 0.0v 109.505n 0.0v 119.495n 0.0v 119.505n 1.8v 129.495n 1.8v 129.505n 1.8v 139.495n 1.8v 139.505n 1.8v 149.495n 1.8v 149.505n 1.8v 159.495n 1.8v 159.505n 1.8v 169.495n 1.8v 169.505n 1.8v 179.495n 1.8v 179.505n 1.8v 189.495n 1.8v 189.505n 1.8v 199.495n 1.8v 199.505n 1.8v 209.495n 1.8v 209.505n 1.8v 219.495n 1.8v 219.505n 0.0v 229.495n 0.0v 229.505n 0.0v 239.495n 0.0v 239.505n 0.0v 249.495n 0.0v 249.505n 0.0v 259.495n 0.0v 259.505n 0.0v 269.495n 0.0v 269.505n 0.0v 279.495n 0.0v 279.505n 0.0v 289.495n 0.0v 289.505n 0.0v 299.495n 0.0v 299.505n 0.0v 309.495n 0.0v 309.505n 0.0v 319.495n 0.0v 319.505n 0.0v 329.495n 0.0v 329.505n 0.0v 339.495n 0.0v 339.505n 0.0v 349.495n 0.0v 349.505n 0.0v 359.495n 0.0v 359.505n 0.0v 369.495n 0.0v 369.505n 0.0v 379.495n 0.0v 379.505n 0.0v 389.495n 0.0v 389.505n 0.0v 399.495n 0.0v 399.505n 0.0v 409.495n 0.0v 409.505n 0.0v 419.495n 0.0v 419.505n 0.0v 429.495n 0.0v 429.505n 0.0v 439.495n 0.0v 439.505n 1.8v 449.495n 1.8v 449.505n 1.8v 459.495n 1.8v 459.505n 1.8v 469.495n 1.8v 469.505n 1.8v 479.495n 1.8v 479.505n 1.8v 489.495n 1.8v 489.505n 1.8v 499.495n 1.8v 499.505n 1.8v 509.495n 1.8v 509.505n 0.0v 519.495n 0.0v 519.505n 0.0v 529.495n 0.0v 529.505n 0.0v 539.495n 0.0v 539.505n 0.0v 549.495n 0.0v 549.505n 1.8v 559.495n 1.8v 559.505n 1.8v 569.495n 1.8v 569.505n 1.8v 579.495n 1.8v 579.505n 0.0v 589.495n 0.0v 589.505n 1.8v 599.495n 1.8v 599.505n 1.8v 609.495n 1.8v 609.505n 1.8v 619.495n 1.8v 619.505n 1.8v 629.495n 1.8v 629.505n 1.8v 639.495n 1.8v 639.505n 1.8v 649.495n 1.8v 649.505n 1.8v 659.495n 1.8v 659.505n 1.8v 669.495n 1.8v 669.505n 0.0v 679.495n 0.0v 679.505n 0.0v 689.495n 0.0v 689.505n 0.0v 699.495n 0.0v 699.505n 0.0v 709.495n 0.0v 709.505n 0.0v 719.495n 0.0v 719.505n 0.0v 729.495n 0.0v 729.505n 1.8v 739.495n 1.8v 739.505n 0.0v 749.495n 0.0v 749.505n 0.0v 759.495n 0.0v 759.505n 1.8v 769.495n 1.8v 769.505n 0.0v 779.495n 0.0v 779.505n 1.8v 789.495n 1.8v 789.505n 1.8v 799.495n 1.8v 799.505n 0.0v 809.495n 0.0v 809.505n 0.0v 819.495n 0.0v 819.505n 0.0v 829.495n 0.0v 829.505n 0.0v 839.495n 0.0v 839.505n 0.0v 849.495n 0.0v 849.505n 0.0v 859.495n 0.0v 859.505n 0.0v 869.495n 0.0v 869.505n 0.0v 879.495n 0.0v 879.505n 0.0v 889.495n 0.0v 889.505n 0.0v 899.495n 0.0v 899.505n 0.0v 909.495n 0.0v 909.505n 0.0v 919.495n 0.0v 919.505n 1.8v 929.495n 1.8v 929.505n 1.8v 939.495n 1.8v 939.505n 1.8v 949.495n 1.8v 949.505n 1.8v 959.495n 1.8v 959.505n 1.8v 969.495n 1.8v 969.505n 0.0v 979.495n 0.0v 979.505n 0.0v 989.495n 0.0v 989.505n 0.0v 999.495n 0.0v 999.505n 1.8v 1009.495n 1.8v 1009.505n 1.8v 1019.495n 1.8v 1019.505n 0.0v 1029.495n 0.0v 1029.505n 0.0v 1039.495n 0.0v 1039.505n 0.0v 1049.495n 0.0v 1049.505n 0.0v 1059.495n 0.0v 1059.505n 0.0v 1069.495n 0.0v 1069.505n 0.0v 1079.495n 0.0v 1079.505n 0.0v 1089.495n 0.0v 1089.505n 0.0v 1099.495n 0.0v 1099.505n 0.0v 1109.495n 0.0v 1109.505n 0.0v 1119.495n 0.0v 1119.505n 0.0v 1129.495n 0.0v 1129.505n 0.0v 1139.495n 0.0v 1139.505n 0.0v 1149.495n 0.0v 1149.505n 0.0v 1159.495n 0.0v 1159.505n 0.0v 1169.495n 0.0v 1169.505n 1.8v 1179.495n 1.8v 1179.505n 1.8v 1189.495n 1.8v 1189.505n 1.8v 1199.495n 1.8v 1199.505n 0.0v 1209.495n 0.0v 1209.505n 0.0v 1219.495n 0.0v 1219.505n 0.0v 1229.495n 0.0v 1229.505n 0.0v 1239.495n 0.0v 1239.505n 0.0v 1249.495n 0.0v 1249.505n 1.8v 1259.495n 1.8v 1259.505n 1.8v 1269.495n 1.8v 1269.505n 0.0v 1279.495n 0.0v 1279.505n 0.0v 1289.495n 0.0v 1289.505n 0.0v 1299.495n 0.0v 1299.505n 0.0v 1309.495n 0.0v 1309.505n 0.0v 1319.495n 0.0v 1319.505n 0.0v 1329.495n 0.0v 1329.505n 0.0v 1339.495n 0.0v 1339.505n 0.0v 1349.495n 0.0v 1349.505n 1.8v 1359.495n 1.8v 1359.505n 1.8v 1369.495n 1.8v 1369.505n 1.8v 1379.495n 1.8v 1379.505n 1.8v 1389.495n 1.8v 1389.505n 1.8v 1399.495n 1.8v 1399.505n 1.8v 1409.495n 1.8v 1409.505n 1.8v 1419.495n 1.8v 1419.505n 1.8v 1429.495n 1.8v 1429.505n 1.8v 1439.495n 1.8v 1439.505n 1.8v 1449.495n 1.8v 1449.505n 1.8v 1459.495n 1.8v 1459.505n 1.8v 1469.495n 1.8v 1469.505n 0.0v 1479.495n 0.0v 1479.505n 0.0v 1489.495n 0.0v 1489.505n 0.0v 1499.495n 0.0v 1499.505n 0.0v 1509.495n 0.0v 1509.505n 0.0v 1519.495n 0.0v 1519.505n 0.0v 1529.495n 0.0v 1529.505n 0.0v 1539.495n 0.0v 1539.505n 0.0v 1549.495n 0.0v 1549.505n 0.0v 1559.495n 0.0v 1559.505n 1.8v 1569.495n 1.8v 1569.505n 1.8v 1579.495n 1.8v 1579.505n 1.8v 1589.495n 1.8v 1589.505n 0.0v 1599.495n 0.0v 1599.505n 0.0v 1609.495n 0.0v 1609.505n 0.0v 1619.495n 0.0v 1619.505n 0.0v 1629.495n 0.0v 1629.505n 0.0v 1639.495n 0.0v 1639.505n 1.8v 1649.495n 1.8v 1649.505n 1.8v 1659.495n 1.8v 1659.505n 1.8v 1669.495n 1.8v 1669.505n 1.8v 1679.495n 1.8v 1679.505n 1.8v 1689.495n 1.8v 1689.505n 1.8v 1699.495n 1.8v 1699.505n 1.8v 1709.495n 1.8v 1709.505n 1.8v 1719.495n 1.8v 1719.505n 1.8v 1729.495n 1.8v 1729.505n 1.8v 1739.495n 1.8v 1739.505n 1.8v 1749.495n 1.8v 1749.505n 1.8v 1759.495n 1.8v 1759.505n 1.8v 1769.495n 1.8v 1769.505n 1.8v 1779.495n 1.8v 1779.505n 1.8v 1789.495n 1.8v 1789.505n 1.8v 1799.495n 1.8v 1799.505n 0.0v 1809.495n 0.0v 1809.505n 1.8v 1819.495n 1.8v 1819.505n 1.8v 1829.495n 1.8v 1829.505n 1.8v 1839.495n 1.8v 1839.505n 1.8v 1849.495n 1.8v 1849.505n 1.8v 1859.495n 1.8v 1859.505n 1.8v 1869.495n 1.8v 1869.505n 1.8v 1879.495n 1.8v 1879.505n 0.0v 1889.495n 0.0v 1889.505n 0.0v 1899.495n 0.0v 1899.505n 0.0v 1909.495n 0.0v 1909.505n 0.0v 1919.495n 0.0v 1919.505n 0.0v 1929.495n 0.0v 1929.505n 1.8v 1939.495n 1.8v 1939.505n 1.8v 1949.495n 1.8v 1949.505n 1.8v 1959.495n 1.8v 1959.505n 1.8v 1969.495n 1.8v 1969.505n 1.8v 1979.495n 1.8v 1979.505n 0.0v 1989.495n 0.0v 1989.505n 0.0v 1999.495n 0.0v 1999.505n 0.0v 2009.495n 0.0v 2009.505n 1.8v 2019.495n 1.8v 2019.505n 1.8v 2029.495n 1.8v 2029.505n 1.8v 2039.495n 1.8v 2039.505n 1.8v 2049.495n 1.8v 2049.505n 1.8v )
* (time, data): [(0, 0), (10, 0), (20, 1), (30, 1), (40, 1), (50, 0), (60, 1), (70, 1), (80, 0), (90, 1), (100, 0), (110, 0), (120, 0), (130, 1), (140, 1), (150, 1), (160, 1), (170, 0), (180, 1), (190, 0), (200, 1), (210, 1), (220, 0), (230, 1), (240, 1), (250, 1), (260, 1), (270, 0), (280, 1), (290, 1), (300, 1), (310, 0), (320, 1), (330, 1), (340, 1), (350, 1), (360, 1), (370, 1), (380, 1), (390, 1), (400, 1), (410, 1), (420, 1), (430, 0), (440, 1), (450, 1), (460, 1), (470, 1), (480, 1), (490, 0), (500, 0), (510, 1), (520, 1), (530, 1), (540, 1), (550, 1), (560, 1), (570, 1), (580, 1), (590, 1), (600, 1), (610, 1), (620, 1), (630, 1), (640, 1), (650, 1), (660, 1), (670, 1), (680, 1), (690, 1), (700, 1), (710, 1), (720, 1), (730, 0), (740, 0), (750, 1), (760, 0), (770, 1), (780, 1), (790, 1), (800, 0), (810, 1), (820, 1), (830, 1), (840, 1), (850, 1), (860, 1), (870, 0), (880, 1), (890, 0), (900, 1), (910, 1), (920, 1), (930, 0), (940, 0), (950, 1), (960, 1), (970, 1), (980, 1), (990, 1), (1000, 0), (1010, 0), (1020, 0), (1030, 0), (1040, 0), (1050, 1), (1060, 0), (1070, 1), (1080, 1), (1090, 0), (1100, 0), (1110, 0), (1120, 1), (1130, 1), (1140, 1), (1150, 0), (1160, 1), (1170, 0), (1180, 1), (1190, 1), (1200, 0), (1210, 0), (1220, 0), (1230, 0), (1240, 1), (1250, 1), (1260, 0), (1270, 1), (1280, 1), (1290, 1), (1300, 1), (1310, 1), (1320, 0), (1330, 0), (1340, 1), (1350, 0), (1360, 1), (1370, 0), (1380, 1), (1390, 1), (1400, 1), (1410, 1), (1420, 1), (1430, 1), (1440, 1), (1450, 0), (1460, 0), (1470, 1), (1480, 0), (1490, 0), (1500, 0), (1510, 0), (1520, 1), (1530, 1), (1540, 1), (1550, 1), (1560, 1), (1570, 0), (1580, 1), (1590, 0), (1600, 1), (1610, 1), (1620, 0), (1630, 0), (1640, 1), (1650, 1), (1660, 1), (1670, 0), (1680, 0), (1690, 1), (1700, 1), (1710, 0), (1720, 1), (1730, 1), (1740, 1), (1750, 1), (1760, 1), (1770, 1), (1780, 1), (1790, 0), (1800, 1), (1810, 0), (1820, 0), (1830, 0), (1840, 0), (1850, 0), (1860, 1), (1870, 1), (1880, 1), (1890, 0), (1900, 0), (1910, 0), (1920, 0), (1930, 0), (1940, 1), (1950, 1), (1960, 1), (1970, 0), (1980, 0), (1990, 0), (2000, 1), (2010, 0), (2020, 0), (2030, 0), (2040, 0), (2050, 0)]
Va0_0  a0_0  0 PWL (0n 0.0v 9.495n 0.0v 9.505n 0.0v 19.495n 0.0v 19.505n 1.8v 29.495n 1.8v 29.505n 1.8v 39.495n 1.8v 39.505n 1.8v 49.495n 1.8v 49.505n 0.0v 59.495n 0.0v 59.505n 1.8v 69.495n 1.8v 69.505n 1.8v 79.495n 1.8v 79.505n 0.0v 89.495n 0.0v 89.505n 1.8v 99.495n 1.8v 99.505n 0.0v 109.495n 0.0v 109.505n 0.0v 119.495n 0.0v 119.505n 0.0v 129.495n 0.0v 129.505n 1.8v 139.495n 1.8v 139.505n 1.8v 149.495n 1.8v 149.505n 1.8v 159.495n 1.8v 159.505n 1.8v 169.495n 1.8v 169.505n 0.0v 179.495n 0.0v 179.505n 1.8v 189.495n 1.8v 189.505n 0.0v 199.495n 0.0v 199.505n 1.8v 209.495n 1.8v 209.505n 1.8v 219.495n 1.8v 219.505n 0.0v 229.495n 0.0v 229.505n 1.8v 239.495n 1.8v 239.505n 1.8v 249.495n 1.8v 249.505n 1.8v 259.495n 1.8v 259.505n 1.8v 269.495n 1.8v 269.505n 0.0v 279.495n 0.0v 279.505n 1.8v 289.495n 1.8v 289.505n 1.8v 299.495n 1.8v 299.505n 1.8v 309.495n 1.8v 309.505n 0.0v 319.495n 0.0v 319.505n 1.8v 329.495n 1.8v 329.505n 1.8v 339.495n 1.8v 339.505n 1.8v 349.495n 1.8v 349.505n 1.8v 359.495n 1.8v 359.505n 1.8v 369.495n 1.8v 369.505n 1.8v 379.495n 1.8v 379.505n 1.8v 389.495n 1.8v 389.505n 1.8v 399.495n 1.8v 399.505n 1.8v 409.495n 1.8v 409.505n 1.8v 419.495n 1.8v 419.505n 1.8v 429.495n 1.8v 429.505n 0.0v 439.495n 0.0v 439.505n 1.8v 449.495n 1.8v 449.505n 1.8v 459.495n 1.8v 459.505n 1.8v 469.495n 1.8v 469.505n 1.8v 479.495n 1.8v 479.505n 1.8v 489.495n 1.8v 489.505n 0.0v 499.495n 0.0v 499.505n 0.0v 509.495n 0.0v 509.505n 1.8v 519.495n 1.8v 519.505n 1.8v 529.495n 1.8v 529.505n 1.8v 539.495n 1.8v 539.505n 1.8v 549.495n 1.8v 549.505n 1.8v 559.495n 1.8v 559.505n 1.8v 569.495n 1.8v 569.505n 1.8v 579.495n 1.8v 579.505n 1.8v 589.495n 1.8v 589.505n 1.8v 599.495n 1.8v 599.505n 1.8v 609.495n 1.8v 609.505n 1.8v 619.495n 1.8v 619.505n 1.8v 629.495n 1.8v 629.505n 1.8v 639.495n 1.8v 639.505n 1.8v 649.495n 1.8v 649.505n 1.8v 659.495n 1.8v 659.505n 1.8v 669.495n 1.8v 669.505n 1.8v 679.495n 1.8v 679.505n 1.8v 689.495n 1.8v 689.505n 1.8v 699.495n 1.8v 699.505n 1.8v 709.495n 1.8v 709.505n 1.8v 719.495n 1.8v 719.505n 1.8v 729.495n 1.8v 729.505n 0.0v 739.495n 0.0v 739.505n 0.0v 749.495n 0.0v 749.505n 1.8v 759.495n 1.8v 759.505n 0.0v 769.495n 0.0v 769.505n 1.8v 779.495n 1.8v 779.505n 1.8v 789.495n 1.8v 789.505n 1.8v 799.495n 1.8v 799.505n 0.0v 809.495n 0.0v 809.505n 1.8v 819.495n 1.8v 819.505n 1.8v 829.495n 1.8v 829.505n 1.8v 839.495n 1.8v 839.505n 1.8v 849.495n 1.8v 849.505n 1.8v 859.495n 1.8v 859.505n 1.8v 869.495n 1.8v 869.505n 0.0v 879.495n 0.0v 879.505n 1.8v 889.495n 1.8v 889.505n 0.0v 899.495n 0.0v 899.505n 1.8v 909.495n 1.8v 909.505n 1.8v 919.495n 1.8v 919.505n 1.8v 929.495n 1.8v 929.505n 0.0v 939.495n 0.0v 939.505n 0.0v 949.495n 0.0v 949.505n 1.8v 959.495n 1.8v 959.505n 1.8v 969.495n 1.8v 969.505n 1.8v 979.495n 1.8v 979.505n 1.8v 989.495n 1.8v 989.505n 1.8v 999.495n 1.8v 999.505n 0.0v 1009.495n 0.0v 1009.505n 0.0v 1019.495n 0.0v 1019.505n 0.0v 1029.495n 0.0v 1029.505n 0.0v 1039.495n 0.0v 1039.505n 0.0v 1049.495n 0.0v 1049.505n 1.8v 1059.495n 1.8v 1059.505n 0.0v 1069.495n 0.0v 1069.505n 1.8v 1079.495n 1.8v 1079.505n 1.8v 1089.495n 1.8v 1089.505n 0.0v 1099.495n 0.0v 1099.505n 0.0v 1109.495n 0.0v 1109.505n 0.0v 1119.495n 0.0v 1119.505n 1.8v 1129.495n 1.8v 1129.505n 1.8v 1139.495n 1.8v 1139.505n 1.8v 1149.495n 1.8v 1149.505n 0.0v 1159.495n 0.0v 1159.505n 1.8v 1169.495n 1.8v 1169.505n 0.0v 1179.495n 0.0v 1179.505n 1.8v 1189.495n 1.8v 1189.505n 1.8v 1199.495n 1.8v 1199.505n 0.0v 1209.495n 0.0v 1209.505n 0.0v 1219.495n 0.0v 1219.505n 0.0v 1229.495n 0.0v 1229.505n 0.0v 1239.495n 0.0v 1239.505n 1.8v 1249.495n 1.8v 1249.505n 1.8v 1259.495n 1.8v 1259.505n 0.0v 1269.495n 0.0v 1269.505n 1.8v 1279.495n 1.8v 1279.505n 1.8v 1289.495n 1.8v 1289.505n 1.8v 1299.495n 1.8v 1299.505n 1.8v 1309.495n 1.8v 1309.505n 1.8v 1319.495n 1.8v 1319.505n 0.0v 1329.495n 0.0v 1329.505n 0.0v 1339.495n 0.0v 1339.505n 1.8v 1349.495n 1.8v 1349.505n 0.0v 1359.495n 0.0v 1359.505n 1.8v 1369.495n 1.8v 1369.505n 0.0v 1379.495n 0.0v 1379.505n 1.8v 1389.495n 1.8v 1389.505n 1.8v 1399.495n 1.8v 1399.505n 1.8v 1409.495n 1.8v 1409.505n 1.8v 1419.495n 1.8v 1419.505n 1.8v 1429.495n 1.8v 1429.505n 1.8v 1439.495n 1.8v 1439.505n 1.8v 1449.495n 1.8v 1449.505n 0.0v 1459.495n 0.0v 1459.505n 0.0v 1469.495n 0.0v 1469.505n 1.8v 1479.495n 1.8v 1479.505n 0.0v 1489.495n 0.0v 1489.505n 0.0v 1499.495n 0.0v 1499.505n 0.0v 1509.495n 0.0v 1509.505n 0.0v 1519.495n 0.0v 1519.505n 1.8v 1529.495n 1.8v 1529.505n 1.8v 1539.495n 1.8v 1539.505n 1.8v 1549.495n 1.8v 1549.505n 1.8v 1559.495n 1.8v 1559.505n 1.8v 1569.495n 1.8v 1569.505n 0.0v 1579.495n 0.0v 1579.505n 1.8v 1589.495n 1.8v 1589.505n 0.0v 1599.495n 0.0v 1599.505n 1.8v 1609.495n 1.8v 1609.505n 1.8v 1619.495n 1.8v 1619.505n 0.0v 1629.495n 0.0v 1629.505n 0.0v 1639.495n 0.0v 1639.505n 1.8v 1649.495n 1.8v 1649.505n 1.8v 1659.495n 1.8v 1659.505n 1.8v 1669.495n 1.8v 1669.505n 0.0v 1679.495n 0.0v 1679.505n 0.0v 1689.495n 0.0v 1689.505n 1.8v 1699.495n 1.8v 1699.505n 1.8v 1709.495n 1.8v 1709.505n 0.0v 1719.495n 0.0v 1719.505n 1.8v 1729.495n 1.8v 1729.505n 1.8v 1739.495n 1.8v 1739.505n 1.8v 1749.495n 1.8v 1749.505n 1.8v 1759.495n 1.8v 1759.505n 1.8v 1769.495n 1.8v 1769.505n 1.8v 1779.495n 1.8v 1779.505n 1.8v 1789.495n 1.8v 1789.505n 0.0v 1799.495n 0.0v 1799.505n 1.8v 1809.495n 1.8v 1809.505n 0.0v 1819.495n 0.0v 1819.505n 0.0v 1829.495n 0.0v 1829.505n 0.0v 1839.495n 0.0v 1839.505n 0.0v 1849.495n 0.0v 1849.505n 0.0v 1859.495n 0.0v 1859.505n 1.8v 1869.495n 1.8v 1869.505n 1.8v 1879.495n 1.8v 1879.505n 1.8v 1889.495n 1.8v 1889.505n 0.0v 1899.495n 0.0v 1899.505n 0.0v 1909.495n 0.0v 1909.505n 0.0v 1919.495n 0.0v 1919.505n 0.0v 1929.495n 0.0v 1929.505n 0.0v 1939.495n 0.0v 1939.505n 1.8v 1949.495n 1.8v 1949.505n 1.8v 1959.495n 1.8v 1959.505n 1.8v 1969.495n 1.8v 1969.505n 0.0v 1979.495n 0.0v 1979.505n 0.0v 1989.495n 0.0v 1989.505n 0.0v 1999.495n 0.0v 1999.505n 1.8v 2009.495n 1.8v 2009.505n 0.0v 2019.495n 0.0v 2019.505n 0.0v 2029.495n 0.0v 2029.505n 0.0v 2039.495n 0.0v 2039.505n 0.0v 2049.495n 0.0v 2049.505n 0.0v )
* (time, data): [(0, 0), (10, 1), (20, 1), (30, 1), (40, 1), (50, 1), (60, 1), (70, 1), (80, 1), (90, 1), (100, 1), (110, 1), (120, 1), (130, 1), (140, 1), (150, 1), (160, 1), (170, 1), (180, 1), (190, 1), (200, 0), (210, 1), (220, 1), (230, 1), (240, 1), (250, 1), (260, 1), (270, 1), (280, 1), (290, 1), (300, 1), (310, 1), (320, 1), (330, 1), (340, 1), (350, 0), (360, 0), (370, 1), (380, 1), (390, 0), (400, 0), (410, 1), (420, 1), (430, 1), (440, 1), (450, 1), (460, 0), (470, 0), (480, 0), (490, 1), (500, 1), (510, 0), (520, 0), (530, 1), (540, 1), (550, 0), (560, 1), (570, 1), (580, 0), (590, 0), (600, 0), (610, 0), (620, 1), (630, 1), (640, 1), (650, 1), (660, 0), (670, 0), (680, 0), (690, 0), (700, 0), (710, 0), (720, 0), (730, 0), (740, 0), (750, 0), (760, 0), (770, 0), (780, 1), (790, 0), (800, 1), (810, 0), (820, 0), (830, 1), (840, 0), (850, 0), (860, 0), (870, 1), (880, 1), (890, 1), (900, 1), (910, 1), (920, 0), (930, 0), (940, 1), (950, 1), (960, 0), (970, 0), (980, 0), (990, 0), (1000, 1), (1010, 1), (1020, 1), (1030, 1), (1040, 1), (1050, 1), (1060, 0), (1070, 0), (1080, 1), (1090, 1), (1100, 1), (1110, 0), (1120, 1), (1130, 1), (1140, 0), (1150, 0), (1160, 0), (1170, 1), (1180, 1), (1190, 0), (1200, 1), (1210, 0), (1220, 0), (1230, 1), (1240, 1), (1250, 1), (1260, 0), (1270, 1), (1280, 1), (1290, 1), (1300, 1), (1310, 0), (1320, 1), (1330, 1), (1340, 0), (1350, 1), (1360, 0), (1370, 0), (1380, 1), (1390, 0), (1400, 0), (1410, 0), (1420, 0), (1430, 1), (1440, 0), (1450, 1), (1460, 0), (1470, 1), (1480, 0), (1490, 1), (1500, 1), (1510, 0), (1520, 0), (1530, 1), (1540, 1), (1550, 0), (1560, 1), (1570, 1), (1580, 1), (1590, 1), (1600, 0), (1610, 0), (1620, 0), (1630, 0), (1640, 0), (1650, 1), (1660, 0), (1670, 0), (1680, 0), (1690, 0), (1700, 0), (1710, 0), (1720, 1), (1730, 1), (1740, 1), (1750, 1), (1760, 0), (1770, 0), (1780, 0), (1790, 0), (1800, 0), (1810, 0), (1820, 1), (1830, 0), (1840, 0), (1850, 0), (1860, 1), (1870, 1), (1880, 0), (1890, 0), (1900, 0), (1910, 1), (1920, 1), (1930, 1), (1940, 0), (1950, 1), (1960, 1), (1970, 1), (1980, 1), (1990, 0), (2000, 1), (2010, 1), (2020, 1), (2030, 1), (2040, 1), (2050, 1)]
Va0_1  a0_1  0 PWL (0n 0.0v 9.495n 0.0v 9.505n 1.8v 19.495n 1.8v 19.505n 1.8v 29.495n 1.8v 29.505n 1.8v 39.495n 1.8v 39.505n 1.8v 49.495n 1.8v 49.505n 1.8v 59.495n 1.8v 59.505n 1.8v 69.495n 1.8v 69.505n 1.8v 79.495n 1.8v 79.505n 1.8v 89.495n 1.8v 89.505n 1.8v 99.495n 1.8v 99.505n 1.8v 109.495n 1.8v 109.505n 1.8v 119.495n 1.8v 119.505n 1.8v 129.495n 1.8v 129.505n 1.8v 139.495n 1.8v 139.505n 1.8v 149.495n 1.8v 149.505n 1.8v 159.495n 1.8v 159.505n 1.8v 169.495n 1.8v 169.505n 1.8v 179.495n 1.8v 179.505n 1.8v 189.495n 1.8v 189.505n 1.8v 199.495n 1.8v 199.505n 0.0v 209.495n 0.0v 209.505n 1.8v 219.495n 1.8v 219.505n 1.8v 229.495n 1.8v 229.505n 1.8v 239.495n 1.8v 239.505n 1.8v 249.495n 1.8v 249.505n 1.8v 259.495n 1.8v 259.505n 1.8v 269.495n 1.8v 269.505n 1.8v 279.495n 1.8v 279.505n 1.8v 289.495n 1.8v 289.505n 1.8v 299.495n 1.8v 299.505n 1.8v 309.495n 1.8v 309.505n 1.8v 319.495n 1.8v 319.505n 1.8v 329.495n 1.8v 329.505n 1.8v 339.495n 1.8v 339.505n 1.8v 349.495n 1.8v 349.505n 0.0v 359.495n 0.0v 359.505n 0.0v 369.495n 0.0v 369.505n 1.8v 379.495n 1.8v 379.505n 1.8v 389.495n 1.8v 389.505n 0.0v 399.495n 0.0v 399.505n 0.0v 409.495n 0.0v 409.505n 1.8v 419.495n 1.8v 419.505n 1.8v 429.495n 1.8v 429.505n 1.8v 439.495n 1.8v 439.505n 1.8v 449.495n 1.8v 449.505n 1.8v 459.495n 1.8v 459.505n 0.0v 469.495n 0.0v 469.505n 0.0v 479.495n 0.0v 479.505n 0.0v 489.495n 0.0v 489.505n 1.8v 499.495n 1.8v 499.505n 1.8v 509.495n 1.8v 509.505n 0.0v 519.495n 0.0v 519.505n 0.0v 529.495n 0.0v 529.505n 1.8v 539.495n 1.8v 539.505n 1.8v 549.495n 1.8v 549.505n 0.0v 559.495n 0.0v 559.505n 1.8v 569.495n 1.8v 569.505n 1.8v 579.495n 1.8v 579.505n 0.0v 589.495n 0.0v 589.505n 0.0v 599.495n 0.0v 599.505n 0.0v 609.495n 0.0v 609.505n 0.0v 619.495n 0.0v 619.505n 1.8v 629.495n 1.8v 629.505n 1.8v 639.495n 1.8v 639.505n 1.8v 649.495n 1.8v 649.505n 1.8v 659.495n 1.8v 659.505n 0.0v 669.495n 0.0v 669.505n 0.0v 679.495n 0.0v 679.505n 0.0v 689.495n 0.0v 689.505n 0.0v 699.495n 0.0v 699.505n 0.0v 709.495n 0.0v 709.505n 0.0v 719.495n 0.0v 719.505n 0.0v 729.495n 0.0v 729.505n 0.0v 739.495n 0.0v 739.505n 0.0v 749.495n 0.0v 749.505n 0.0v 759.495n 0.0v 759.505n 0.0v 769.495n 0.0v 769.505n 0.0v 779.495n 0.0v 779.505n 1.8v 789.495n 1.8v 789.505n 0.0v 799.495n 0.0v 799.505n 1.8v 809.495n 1.8v 809.505n 0.0v 819.495n 0.0v 819.505n 0.0v 829.495n 0.0v 829.505n 1.8v 839.495n 1.8v 839.505n 0.0v 849.495n 0.0v 849.505n 0.0v 859.495n 0.0v 859.505n 0.0v 869.495n 0.0v 869.505n 1.8v 879.495n 1.8v 879.505n 1.8v 889.495n 1.8v 889.505n 1.8v 899.495n 1.8v 899.505n 1.8v 909.495n 1.8v 909.505n 1.8v 919.495n 1.8v 919.505n 0.0v 929.495n 0.0v 929.505n 0.0v 939.495n 0.0v 939.505n 1.8v 949.495n 1.8v 949.505n 1.8v 959.495n 1.8v 959.505n 0.0v 969.495n 0.0v 969.505n 0.0v 979.495n 0.0v 979.505n 0.0v 989.495n 0.0v 989.505n 0.0v 999.495n 0.0v 999.505n 1.8v 1009.495n 1.8v 1009.505n 1.8v 1019.495n 1.8v 1019.505n 1.8v 1029.495n 1.8v 1029.505n 1.8v 1039.495n 1.8v 1039.505n 1.8v 1049.495n 1.8v 1049.505n 1.8v 1059.495n 1.8v 1059.505n 0.0v 1069.495n 0.0v 1069.505n 0.0v 1079.495n 0.0v 1079.505n 1.8v 1089.495n 1.8v 1089.505n 1.8v 1099.495n 1.8v 1099.505n 1.8v 1109.495n 1.8v 1109.505n 0.0v 1119.495n 0.0v 1119.505n 1.8v 1129.495n 1.8v 1129.505n 1.8v 1139.495n 1.8v 1139.505n 0.0v 1149.495n 0.0v 1149.505n 0.0v 1159.495n 0.0v 1159.505n 0.0v 1169.495n 0.0v 1169.505n 1.8v 1179.495n 1.8v 1179.505n 1.8v 1189.495n 1.8v 1189.505n 0.0v 1199.495n 0.0v 1199.505n 1.8v 1209.495n 1.8v 1209.505n 0.0v 1219.495n 0.0v 1219.505n 0.0v 1229.495n 0.0v 1229.505n 1.8v 1239.495n 1.8v 1239.505n 1.8v 1249.495n 1.8v 1249.505n 1.8v 1259.495n 1.8v 1259.505n 0.0v 1269.495n 0.0v 1269.505n 1.8v 1279.495n 1.8v 1279.505n 1.8v 1289.495n 1.8v 1289.505n 1.8v 1299.495n 1.8v 1299.505n 1.8v 1309.495n 1.8v 1309.505n 0.0v 1319.495n 0.0v 1319.505n 1.8v 1329.495n 1.8v 1329.505n 1.8v 1339.495n 1.8v 1339.505n 0.0v 1349.495n 0.0v 1349.505n 1.8v 1359.495n 1.8v 1359.505n 0.0v 1369.495n 0.0v 1369.505n 0.0v 1379.495n 0.0v 1379.505n 1.8v 1389.495n 1.8v 1389.505n 0.0v 1399.495n 0.0v 1399.505n 0.0v 1409.495n 0.0v 1409.505n 0.0v 1419.495n 0.0v 1419.505n 0.0v 1429.495n 0.0v 1429.505n 1.8v 1439.495n 1.8v 1439.505n 0.0v 1449.495n 0.0v 1449.505n 1.8v 1459.495n 1.8v 1459.505n 0.0v 1469.495n 0.0v 1469.505n 1.8v 1479.495n 1.8v 1479.505n 0.0v 1489.495n 0.0v 1489.505n 1.8v 1499.495n 1.8v 1499.505n 1.8v 1509.495n 1.8v 1509.505n 0.0v 1519.495n 0.0v 1519.505n 0.0v 1529.495n 0.0v 1529.505n 1.8v 1539.495n 1.8v 1539.505n 1.8v 1549.495n 1.8v 1549.505n 0.0v 1559.495n 0.0v 1559.505n 1.8v 1569.495n 1.8v 1569.505n 1.8v 1579.495n 1.8v 1579.505n 1.8v 1589.495n 1.8v 1589.505n 1.8v 1599.495n 1.8v 1599.505n 0.0v 1609.495n 0.0v 1609.505n 0.0v 1619.495n 0.0v 1619.505n 0.0v 1629.495n 0.0v 1629.505n 0.0v 1639.495n 0.0v 1639.505n 0.0v 1649.495n 0.0v 1649.505n 1.8v 1659.495n 1.8v 1659.505n 0.0v 1669.495n 0.0v 1669.505n 0.0v 1679.495n 0.0v 1679.505n 0.0v 1689.495n 0.0v 1689.505n 0.0v 1699.495n 0.0v 1699.505n 0.0v 1709.495n 0.0v 1709.505n 0.0v 1719.495n 0.0v 1719.505n 1.8v 1729.495n 1.8v 1729.505n 1.8v 1739.495n 1.8v 1739.505n 1.8v 1749.495n 1.8v 1749.505n 1.8v 1759.495n 1.8v 1759.505n 0.0v 1769.495n 0.0v 1769.505n 0.0v 1779.495n 0.0v 1779.505n 0.0v 1789.495n 0.0v 1789.505n 0.0v 1799.495n 0.0v 1799.505n 0.0v 1809.495n 0.0v 1809.505n 0.0v 1819.495n 0.0v 1819.505n 1.8v 1829.495n 1.8v 1829.505n 0.0v 1839.495n 0.0v 1839.505n 0.0v 1849.495n 0.0v 1849.505n 0.0v 1859.495n 0.0v 1859.505n 1.8v 1869.495n 1.8v 1869.505n 1.8v 1879.495n 1.8v 1879.505n 0.0v 1889.495n 0.0v 1889.505n 0.0v 1899.495n 0.0v 1899.505n 0.0v 1909.495n 0.0v 1909.505n 1.8v 1919.495n 1.8v 1919.505n 1.8v 1929.495n 1.8v 1929.505n 1.8v 1939.495n 1.8v 1939.505n 0.0v 1949.495n 0.0v 1949.505n 1.8v 1959.495n 1.8v 1959.505n 1.8v 1969.495n 1.8v 1969.505n 1.8v 1979.495n 1.8v 1979.505n 1.8v 1989.495n 1.8v 1989.505n 0.0v 1999.495n 0.0v 1999.505n 1.8v 2009.495n 1.8v 2009.505n 1.8v 2019.495n 1.8v 2019.505n 1.8v 2029.495n 1.8v 2029.505n 1.8v 2039.495n 1.8v 2039.505n 1.8v 2049.495n 1.8v 2049.505n 1.8v )
* (time, data): [(0, 0), (10, 1), (20, 0), (30, 0), (40, 0), (50, 1), (60, 0), (70, 0), (80, 1), (90, 0), (100, 1), (110, 1), (120, 1), (130, 0), (140, 0), (150, 0), (160, 0), (170, 1), (180, 0), (190, 1), (200, 0), (210, 0), (220, 1), (230, 0), (240, 0), (250, 0), (260, 0), (270, 1), (280, 0), (290, 0), (300, 0), (310, 1), (320, 0), (330, 0), (340, 0), (350, 0), (360, 0), (370, 0), (380, 0), (390, 0), (400, 0), (410, 0), (420, 0), (430, 1), (440, 0), (450, 0), (460, 0), (470, 0), (480, 0), (490, 1), (500, 1), (510, 0), (520, 0), (530, 0), (540, 0), (550, 1), (560, 0), (570, 0), (580, 0), (590, 0), (600, 0), (610, 1), (620, 0), (630, 0), (640, 0), (650, 0), (660, 1), (670, 1), (680, 0), (690, 0), (700, 0), (710, 0), (720, 0), (730, 0), (740, 0), (750, 0), (760, 0), (770, 0), (780, 0), (790, 0), (800, 0), (810, 0), (820, 0), (830, 0), (840, 0), (850, 0), (860, 0), (870, 0), (880, 0), (890, 0), (900, 0), (910, 0), (920, 0), (930, 0), (940, 1), (950, 0), (960, 1), (970, 0), (980, 0), (990, 0), (1000, 1), (1010, 1), (1020, 1), (1030, 1), (1040, 1), (1050, 0), (1060, 0), (1070, 1), (1080, 0), (1090, 0), (1100, 0), (1110, 0), (1120, 0), (1130, 0), (1140, 1), (1150, 0), (1160, 1), (1170, 0), (1180, 0), (1190, 1), (1200, 1), (1210, 0), (1220, 0), (1230, 0), (1240, 0), (1250, 0), (1260, 0), (1270, 0), (1280, 0), (1290, 0), (1300, 0), (1310, 0), (1320, 1), (1330, 0), (1340, 0), (1350, 1), (1360, 0), (1370, 0), (1380, 0), (1390, 0), (1400, 0), (1410, 0), (1420, 0), (1430, 0), (1440, 0), (1450, 1), (1460, 1), (1470, 0), (1480, 1), (1490, 1), (1500, 1), (1510, 0), (1520, 0), (1530, 0), (1540, 0), (1550, 0), (1560, 0), (1570, 1), (1580, 0), (1590, 0), (1600, 0), (1610, 0), (1620, 1), (1630, 0), (1640, 0), (1650, 0), (1660, 0), (1670, 1), (1680, 1), (1690, 1), (1700, 1), (1710, 1), (1720, 0), (1730, 0), (1740, 0), (1750, 0), (1760, 0), (1770, 1), (1780, 1), (1790, 0), (1800, 1), (1810, 0), (1820, 0), (1830, 1), (1840, 0), (1850, 0), (1860, 0), (1870, 0), (1880, 1), (1890, 0), (1900, 1), (1910, 1), (1920, 1), (1930, 1), (1940, 0), (1950, 0), (1960, 0), (1970, 0), (1980, 0), (1990, 1), (2000, 0), (2010, 1), (2020, 1), (2030, 1), (2040, 1), (2050, 1)]
Va0_2  a0_2  0 PWL (0n 0.0v 9.495n 0.0v 9.505n 1.8v 19.495n 1.8v 19.505n 0.0v 29.495n 0.0v 29.505n 0.0v 39.495n 0.0v 39.505n 0.0v 49.495n 0.0v 49.505n 1.8v 59.495n 1.8v 59.505n 0.0v 69.495n 0.0v 69.505n 0.0v 79.495n 0.0v 79.505n 1.8v 89.495n 1.8v 89.505n 0.0v 99.495n 0.0v 99.505n 1.8v 109.495n 1.8v 109.505n 1.8v 119.495n 1.8v 119.505n 1.8v 129.495n 1.8v 129.505n 0.0v 139.495n 0.0v 139.505n 0.0v 149.495n 0.0v 149.505n 0.0v 159.495n 0.0v 159.505n 0.0v 169.495n 0.0v 169.505n 1.8v 179.495n 1.8v 179.505n 0.0v 189.495n 0.0v 189.505n 1.8v 199.495n 1.8v 199.505n 0.0v 209.495n 0.0v 209.505n 0.0v 219.495n 0.0v 219.505n 1.8v 229.495n 1.8v 229.505n 0.0v 239.495n 0.0v 239.505n 0.0v 249.495n 0.0v 249.505n 0.0v 259.495n 0.0v 259.505n 0.0v 269.495n 0.0v 269.505n 1.8v 279.495n 1.8v 279.505n 0.0v 289.495n 0.0v 289.505n 0.0v 299.495n 0.0v 299.505n 0.0v 309.495n 0.0v 309.505n 1.8v 319.495n 1.8v 319.505n 0.0v 329.495n 0.0v 329.505n 0.0v 339.495n 0.0v 339.505n 0.0v 349.495n 0.0v 349.505n 0.0v 359.495n 0.0v 359.505n 0.0v 369.495n 0.0v 369.505n 0.0v 379.495n 0.0v 379.505n 0.0v 389.495n 0.0v 389.505n 0.0v 399.495n 0.0v 399.505n 0.0v 409.495n 0.0v 409.505n 0.0v 419.495n 0.0v 419.505n 0.0v 429.495n 0.0v 429.505n 1.8v 439.495n 1.8v 439.505n 0.0v 449.495n 0.0v 449.505n 0.0v 459.495n 0.0v 459.505n 0.0v 469.495n 0.0v 469.505n 0.0v 479.495n 0.0v 479.505n 0.0v 489.495n 0.0v 489.505n 1.8v 499.495n 1.8v 499.505n 1.8v 509.495n 1.8v 509.505n 0.0v 519.495n 0.0v 519.505n 0.0v 529.495n 0.0v 529.505n 0.0v 539.495n 0.0v 539.505n 0.0v 549.495n 0.0v 549.505n 1.8v 559.495n 1.8v 559.505n 0.0v 569.495n 0.0v 569.505n 0.0v 579.495n 0.0v 579.505n 0.0v 589.495n 0.0v 589.505n 0.0v 599.495n 0.0v 599.505n 0.0v 609.495n 0.0v 609.505n 1.8v 619.495n 1.8v 619.505n 0.0v 629.495n 0.0v 629.505n 0.0v 639.495n 0.0v 639.505n 0.0v 649.495n 0.0v 649.505n 0.0v 659.495n 0.0v 659.505n 1.8v 669.495n 1.8v 669.505n 1.8v 679.495n 1.8v 679.505n 0.0v 689.495n 0.0v 689.505n 0.0v 699.495n 0.0v 699.505n 0.0v 709.495n 0.0v 709.505n 0.0v 719.495n 0.0v 719.505n 0.0v 729.495n 0.0v 729.505n 0.0v 739.495n 0.0v 739.505n 0.0v 749.495n 0.0v 749.505n 0.0v 759.495n 0.0v 759.505n 0.0v 769.495n 0.0v 769.505n 0.0v 779.495n 0.0v 779.505n 0.0v 789.495n 0.0v 789.505n 0.0v 799.495n 0.0v 799.505n 0.0v 809.495n 0.0v 809.505n 0.0v 819.495n 0.0v 819.505n 0.0v 829.495n 0.0v 829.505n 0.0v 839.495n 0.0v 839.505n 0.0v 849.495n 0.0v 849.505n 0.0v 859.495n 0.0v 859.505n 0.0v 869.495n 0.0v 869.505n 0.0v 879.495n 0.0v 879.505n 0.0v 889.495n 0.0v 889.505n 0.0v 899.495n 0.0v 899.505n 0.0v 909.495n 0.0v 909.505n 0.0v 919.495n 0.0v 919.505n 0.0v 929.495n 0.0v 929.505n 0.0v 939.495n 0.0v 939.505n 1.8v 949.495n 1.8v 949.505n 0.0v 959.495n 0.0v 959.505n 1.8v 969.495n 1.8v 969.505n 0.0v 979.495n 0.0v 979.505n 0.0v 989.495n 0.0v 989.505n 0.0v 999.495n 0.0v 999.505n 1.8v 1009.495n 1.8v 1009.505n 1.8v 1019.495n 1.8v 1019.505n 1.8v 1029.495n 1.8v 1029.505n 1.8v 1039.495n 1.8v 1039.505n 1.8v 1049.495n 1.8v 1049.505n 0.0v 1059.495n 0.0v 1059.505n 0.0v 1069.495n 0.0v 1069.505n 1.8v 1079.495n 1.8v 1079.505n 0.0v 1089.495n 0.0v 1089.505n 0.0v 1099.495n 0.0v 1099.505n 0.0v 1109.495n 0.0v 1109.505n 0.0v 1119.495n 0.0v 1119.505n 0.0v 1129.495n 0.0v 1129.505n 0.0v 1139.495n 0.0v 1139.505n 1.8v 1149.495n 1.8v 1149.505n 0.0v 1159.495n 0.0v 1159.505n 1.8v 1169.495n 1.8v 1169.505n 0.0v 1179.495n 0.0v 1179.505n 0.0v 1189.495n 0.0v 1189.505n 1.8v 1199.495n 1.8v 1199.505n 1.8v 1209.495n 1.8v 1209.505n 0.0v 1219.495n 0.0v 1219.505n 0.0v 1229.495n 0.0v 1229.505n 0.0v 1239.495n 0.0v 1239.505n 0.0v 1249.495n 0.0v 1249.505n 0.0v 1259.495n 0.0v 1259.505n 0.0v 1269.495n 0.0v 1269.505n 0.0v 1279.495n 0.0v 1279.505n 0.0v 1289.495n 0.0v 1289.505n 0.0v 1299.495n 0.0v 1299.505n 0.0v 1309.495n 0.0v 1309.505n 0.0v 1319.495n 0.0v 1319.505n 1.8v 1329.495n 1.8v 1329.505n 0.0v 1339.495n 0.0v 1339.505n 0.0v 1349.495n 0.0v 1349.505n 1.8v 1359.495n 1.8v 1359.505n 0.0v 1369.495n 0.0v 1369.505n 0.0v 1379.495n 0.0v 1379.505n 0.0v 1389.495n 0.0v 1389.505n 0.0v 1399.495n 0.0v 1399.505n 0.0v 1409.495n 0.0v 1409.505n 0.0v 1419.495n 0.0v 1419.505n 0.0v 1429.495n 0.0v 1429.505n 0.0v 1439.495n 0.0v 1439.505n 0.0v 1449.495n 0.0v 1449.505n 1.8v 1459.495n 1.8v 1459.505n 1.8v 1469.495n 1.8v 1469.505n 0.0v 1479.495n 0.0v 1479.505n 1.8v 1489.495n 1.8v 1489.505n 1.8v 1499.495n 1.8v 1499.505n 1.8v 1509.495n 1.8v 1509.505n 0.0v 1519.495n 0.0v 1519.505n 0.0v 1529.495n 0.0v 1529.505n 0.0v 1539.495n 0.0v 1539.505n 0.0v 1549.495n 0.0v 1549.505n 0.0v 1559.495n 0.0v 1559.505n 0.0v 1569.495n 0.0v 1569.505n 1.8v 1579.495n 1.8v 1579.505n 0.0v 1589.495n 0.0v 1589.505n 0.0v 1599.495n 0.0v 1599.505n 0.0v 1609.495n 0.0v 1609.505n 0.0v 1619.495n 0.0v 1619.505n 1.8v 1629.495n 1.8v 1629.505n 0.0v 1639.495n 0.0v 1639.505n 0.0v 1649.495n 0.0v 1649.505n 0.0v 1659.495n 0.0v 1659.505n 0.0v 1669.495n 0.0v 1669.505n 1.8v 1679.495n 1.8v 1679.505n 1.8v 1689.495n 1.8v 1689.505n 1.8v 1699.495n 1.8v 1699.505n 1.8v 1709.495n 1.8v 1709.505n 1.8v 1719.495n 1.8v 1719.505n 0.0v 1729.495n 0.0v 1729.505n 0.0v 1739.495n 0.0v 1739.505n 0.0v 1749.495n 0.0v 1749.505n 0.0v 1759.495n 0.0v 1759.505n 0.0v 1769.495n 0.0v 1769.505n 1.8v 1779.495n 1.8v 1779.505n 1.8v 1789.495n 1.8v 1789.505n 0.0v 1799.495n 0.0v 1799.505n 1.8v 1809.495n 1.8v 1809.505n 0.0v 1819.495n 0.0v 1819.505n 0.0v 1829.495n 0.0v 1829.505n 1.8v 1839.495n 1.8v 1839.505n 0.0v 1849.495n 0.0v 1849.505n 0.0v 1859.495n 0.0v 1859.505n 0.0v 1869.495n 0.0v 1869.505n 0.0v 1879.495n 0.0v 1879.505n 1.8v 1889.495n 1.8v 1889.505n 0.0v 1899.495n 0.0v 1899.505n 1.8v 1909.495n 1.8v 1909.505n 1.8v 1919.495n 1.8v 1919.505n 1.8v 1929.495n 1.8v 1929.505n 1.8v 1939.495n 1.8v 1939.505n 0.0v 1949.495n 0.0v 1949.505n 0.0v 1959.495n 0.0v 1959.505n 0.0v 1969.495n 0.0v 1969.505n 0.0v 1979.495n 0.0v 1979.505n 0.0v 1989.495n 0.0v 1989.505n 1.8v 1999.495n 1.8v 1999.505n 0.0v 2009.495n 0.0v 2009.505n 1.8v 2019.495n 1.8v 2019.505n 1.8v 2029.495n 1.8v 2029.505n 1.8v 2039.495n 1.8v 2039.505n 1.8v 2049.495n 1.8v 2049.505n 1.8v )
* (time, data): [(0, 0), (10, 1), (20, 0), (30, 0), (40, 0), (50, 1), (60, 1), (70, 0), (80, 1), (90, 1), (100, 1), (110, 1), (120, 1), (130, 0), (140, 1), (150, 1), (160, 1), (170, 1), (180, 1), (190, 1), (200, 0), (210, 1), (220, 1), (230, 0), (240, 0), (250, 1), (260, 1), (270, 1), (280, 0), (290, 0), (300, 1), (310, 1), (320, 1), (330, 1), (340, 1), (350, 0), (360, 0), (370, 1), (380, 0), (390, 0), (400, 0), (410, 0), (420, 0), (430, 1), (440, 1), (450, 1), (460, 0), (470, 0), (480, 0), (490, 1), (500, 1), (510, 0), (520, 0), (530, 1), (540, 1), (550, 1), (560, 0), (570, 1), (580, 0), (590, 0), (600, 0), (610, 1), (620, 0), (630, 0), (640, 0), (650, 0), (660, 1), (670, 1), (680, 0), (690, 0), (700, 0), (710, 0), (720, 0), (730, 0), (740, 0), (750, 0), (760, 0), (770, 0), (780, 0), (790, 0), (800, 0), (810, 0), (820, 0), (830, 1), (840, 0), (850, 0), (860, 0), (870, 0), (880, 1), (890, 0), (900, 0), (910, 1), (920, 0), (930, 0), (940, 1), (950, 0), (960, 1), (970, 0), (980, 0), (990, 0), (1000, 1), (1010, 1), (1020, 1), (1030, 1), (1040, 1), (1050, 1), (1060, 0), (1070, 1), (1080, 1), (1090, 0), (1100, 0), (1110, 0), (1120, 1), (1130, 0), (1140, 1), (1150, 0), (1160, 1), (1170, 0), (1180, 0), (1190, 1), (1200, 1), (1210, 0), (1220, 0), (1230, 0), (1240, 1), (1250, 0), (1260, 0), (1270, 1), (1280, 0), (1290, 0), (1300, 0), (1310, 0), (1320, 1), (1330, 0), (1340, 0), (1350, 1), (1360, 0), (1370, 0), (1380, 0), (1390, 0), (1400, 0), (1410, 0), (1420, 0), (1430, 1), (1440, 0), (1450, 1), (1460, 1), (1470, 0), (1480, 1), (1490, 1), (1500, 1), (1510, 0), (1520, 0), (1530, 1), (1540, 1), (1550, 0), (1560, 0), (1570, 1), (1580, 1), (1590, 0), (1600, 0), (1610, 0), (1620, 1), (1630, 0), (1640, 0), (1650, 1), (1660, 0), (1670, 1), (1680, 1), (1690, 1), (1700, 1), (1710, 1), (1720, 0), (1730, 0), (1740, 0), (1750, 0), (1760, 0), (1770, 1), (1780, 1), (1790, 0), (1800, 1), (1810, 0), (1820, 0), (1830, 1), (1840, 0), (1850, 0), (1860, 0), (1870, 0), (1880, 1), (1890, 0), (1900, 1), (1910, 1), (1920, 1), (1930, 1), (1940, 0), (1950, 0), (1960, 0), (1970, 0), (1980, 0), (1990, 1), (2000, 1), (2010, 1), (2020, 1), (2030, 1), (2040, 1), (2050, 1)]
Va0_3  a0_3  0 PWL (0n 0.0v 9.495n 0.0v 9.505n 1.8v 19.495n 1.8v 19.505n 0.0v 29.495n 0.0v 29.505n 0.0v 39.495n 0.0v 39.505n 0.0v 49.495n 0.0v 49.505n 1.8v 59.495n 1.8v 59.505n 1.8v 69.495n 1.8v 69.505n 0.0v 79.495n 0.0v 79.505n 1.8v 89.495n 1.8v 89.505n 1.8v 99.495n 1.8v 99.505n 1.8v 109.495n 1.8v 109.505n 1.8v 119.495n 1.8v 119.505n 1.8v 129.495n 1.8v 129.505n 0.0v 139.495n 0.0v 139.505n 1.8v 149.495n 1.8v 149.505n 1.8v 159.495n 1.8v 159.505n 1.8v 169.495n 1.8v 169.505n 1.8v 179.495n 1.8v 179.505n 1.8v 189.495n 1.8v 189.505n 1.8v 199.495n 1.8v 199.505n 0.0v 209.495n 0.0v 209.505n 1.8v 219.495n 1.8v 219.505n 1.8v 229.495n 1.8v 229.505n 0.0v 239.495n 0.0v 239.505n 0.0v 249.495n 0.0v 249.505n 1.8v 259.495n 1.8v 259.505n 1.8v 269.495n 1.8v 269.505n 1.8v 279.495n 1.8v 279.505n 0.0v 289.495n 0.0v 289.505n 0.0v 299.495n 0.0v 299.505n 1.8v 309.495n 1.8v 309.505n 1.8v 319.495n 1.8v 319.505n 1.8v 329.495n 1.8v 329.505n 1.8v 339.495n 1.8v 339.505n 1.8v 349.495n 1.8v 349.505n 0.0v 359.495n 0.0v 359.505n 0.0v 369.495n 0.0v 369.505n 1.8v 379.495n 1.8v 379.505n 0.0v 389.495n 0.0v 389.505n 0.0v 399.495n 0.0v 399.505n 0.0v 409.495n 0.0v 409.505n 0.0v 419.495n 0.0v 419.505n 0.0v 429.495n 0.0v 429.505n 1.8v 439.495n 1.8v 439.505n 1.8v 449.495n 1.8v 449.505n 1.8v 459.495n 1.8v 459.505n 0.0v 469.495n 0.0v 469.505n 0.0v 479.495n 0.0v 479.505n 0.0v 489.495n 0.0v 489.505n 1.8v 499.495n 1.8v 499.505n 1.8v 509.495n 1.8v 509.505n 0.0v 519.495n 0.0v 519.505n 0.0v 529.495n 0.0v 529.505n 1.8v 539.495n 1.8v 539.505n 1.8v 549.495n 1.8v 549.505n 1.8v 559.495n 1.8v 559.505n 0.0v 569.495n 0.0v 569.505n 1.8v 579.495n 1.8v 579.505n 0.0v 589.495n 0.0v 589.505n 0.0v 599.495n 0.0v 599.505n 0.0v 609.495n 0.0v 609.505n 1.8v 619.495n 1.8v 619.505n 0.0v 629.495n 0.0v 629.505n 0.0v 639.495n 0.0v 639.505n 0.0v 649.495n 0.0v 649.505n 0.0v 659.495n 0.0v 659.505n 1.8v 669.495n 1.8v 669.505n 1.8v 679.495n 1.8v 679.505n 0.0v 689.495n 0.0v 689.505n 0.0v 699.495n 0.0v 699.505n 0.0v 709.495n 0.0v 709.505n 0.0v 719.495n 0.0v 719.505n 0.0v 729.495n 0.0v 729.505n 0.0v 739.495n 0.0v 739.505n 0.0v 749.495n 0.0v 749.505n 0.0v 759.495n 0.0v 759.505n 0.0v 769.495n 0.0v 769.505n 0.0v 779.495n 0.0v 779.505n 0.0v 789.495n 0.0v 789.505n 0.0v 799.495n 0.0v 799.505n 0.0v 809.495n 0.0v 809.505n 0.0v 819.495n 0.0v 819.505n 0.0v 829.495n 0.0v 829.505n 1.8v 839.495n 1.8v 839.505n 0.0v 849.495n 0.0v 849.505n 0.0v 859.495n 0.0v 859.505n 0.0v 869.495n 0.0v 869.505n 0.0v 879.495n 0.0v 879.505n 1.8v 889.495n 1.8v 889.505n 0.0v 899.495n 0.0v 899.505n 0.0v 909.495n 0.0v 909.505n 1.8v 919.495n 1.8v 919.505n 0.0v 929.495n 0.0v 929.505n 0.0v 939.495n 0.0v 939.505n 1.8v 949.495n 1.8v 949.505n 0.0v 959.495n 0.0v 959.505n 1.8v 969.495n 1.8v 969.505n 0.0v 979.495n 0.0v 979.505n 0.0v 989.495n 0.0v 989.505n 0.0v 999.495n 0.0v 999.505n 1.8v 1009.495n 1.8v 1009.505n 1.8v 1019.495n 1.8v 1019.505n 1.8v 1029.495n 1.8v 1029.505n 1.8v 1039.495n 1.8v 1039.505n 1.8v 1049.495n 1.8v 1049.505n 1.8v 1059.495n 1.8v 1059.505n 0.0v 1069.495n 0.0v 1069.505n 1.8v 1079.495n 1.8v 1079.505n 1.8v 1089.495n 1.8v 1089.505n 0.0v 1099.495n 0.0v 1099.505n 0.0v 1109.495n 0.0v 1109.505n 0.0v 1119.495n 0.0v 1119.505n 1.8v 1129.495n 1.8v 1129.505n 0.0v 1139.495n 0.0v 1139.505n 1.8v 1149.495n 1.8v 1149.505n 0.0v 1159.495n 0.0v 1159.505n 1.8v 1169.495n 1.8v 1169.505n 0.0v 1179.495n 0.0v 1179.505n 0.0v 1189.495n 0.0v 1189.505n 1.8v 1199.495n 1.8v 1199.505n 1.8v 1209.495n 1.8v 1209.505n 0.0v 1219.495n 0.0v 1219.505n 0.0v 1229.495n 0.0v 1229.505n 0.0v 1239.495n 0.0v 1239.505n 1.8v 1249.495n 1.8v 1249.505n 0.0v 1259.495n 0.0v 1259.505n 0.0v 1269.495n 0.0v 1269.505n 1.8v 1279.495n 1.8v 1279.505n 0.0v 1289.495n 0.0v 1289.505n 0.0v 1299.495n 0.0v 1299.505n 0.0v 1309.495n 0.0v 1309.505n 0.0v 1319.495n 0.0v 1319.505n 1.8v 1329.495n 1.8v 1329.505n 0.0v 1339.495n 0.0v 1339.505n 0.0v 1349.495n 0.0v 1349.505n 1.8v 1359.495n 1.8v 1359.505n 0.0v 1369.495n 0.0v 1369.505n 0.0v 1379.495n 0.0v 1379.505n 0.0v 1389.495n 0.0v 1389.505n 0.0v 1399.495n 0.0v 1399.505n 0.0v 1409.495n 0.0v 1409.505n 0.0v 1419.495n 0.0v 1419.505n 0.0v 1429.495n 0.0v 1429.505n 1.8v 1439.495n 1.8v 1439.505n 0.0v 1449.495n 0.0v 1449.505n 1.8v 1459.495n 1.8v 1459.505n 1.8v 1469.495n 1.8v 1469.505n 0.0v 1479.495n 0.0v 1479.505n 1.8v 1489.495n 1.8v 1489.505n 1.8v 1499.495n 1.8v 1499.505n 1.8v 1509.495n 1.8v 1509.505n 0.0v 1519.495n 0.0v 1519.505n 0.0v 1529.495n 0.0v 1529.505n 1.8v 1539.495n 1.8v 1539.505n 1.8v 1549.495n 1.8v 1549.505n 0.0v 1559.495n 0.0v 1559.505n 0.0v 1569.495n 0.0v 1569.505n 1.8v 1579.495n 1.8v 1579.505n 1.8v 1589.495n 1.8v 1589.505n 0.0v 1599.495n 0.0v 1599.505n 0.0v 1609.495n 0.0v 1609.505n 0.0v 1619.495n 0.0v 1619.505n 1.8v 1629.495n 1.8v 1629.505n 0.0v 1639.495n 0.0v 1639.505n 0.0v 1649.495n 0.0v 1649.505n 1.8v 1659.495n 1.8v 1659.505n 0.0v 1669.495n 0.0v 1669.505n 1.8v 1679.495n 1.8v 1679.505n 1.8v 1689.495n 1.8v 1689.505n 1.8v 1699.495n 1.8v 1699.505n 1.8v 1709.495n 1.8v 1709.505n 1.8v 1719.495n 1.8v 1719.505n 0.0v 1729.495n 0.0v 1729.505n 0.0v 1739.495n 0.0v 1739.505n 0.0v 1749.495n 0.0v 1749.505n 0.0v 1759.495n 0.0v 1759.505n 0.0v 1769.495n 0.0v 1769.505n 1.8v 1779.495n 1.8v 1779.505n 1.8v 1789.495n 1.8v 1789.505n 0.0v 1799.495n 0.0v 1799.505n 1.8v 1809.495n 1.8v 1809.505n 0.0v 1819.495n 0.0v 1819.505n 0.0v 1829.495n 0.0v 1829.505n 1.8v 1839.495n 1.8v 1839.505n 0.0v 1849.495n 0.0v 1849.505n 0.0v 1859.495n 0.0v 1859.505n 0.0v 1869.495n 0.0v 1869.505n 0.0v 1879.495n 0.0v 1879.505n 1.8v 1889.495n 1.8v 1889.505n 0.0v 1899.495n 0.0v 1899.505n 1.8v 1909.495n 1.8v 1909.505n 1.8v 1919.495n 1.8v 1919.505n 1.8v 1929.495n 1.8v 1929.505n 1.8v 1939.495n 1.8v 1939.505n 0.0v 1949.495n 0.0v 1949.505n 0.0v 1959.495n 0.0v 1959.505n 0.0v 1969.495n 0.0v 1969.505n 0.0v 1979.495n 0.0v 1979.505n 0.0v 1989.495n 0.0v 1989.505n 1.8v 1999.495n 1.8v 1999.505n 1.8v 2009.495n 1.8v 2009.505n 1.8v 2019.495n 1.8v 2019.505n 1.8v 2029.495n 1.8v 2029.505n 1.8v 2039.495n 1.8v 2039.505n 1.8v 2049.495n 1.8v 2049.505n 1.8v )
* (time, data): [(0, 0), (10, 1), (20, 0), (30, 0), (40, 0), (50, 1), (60, 1), (70, 0), (80, 1), (90, 1), (100, 1), (110, 1), (120, 1), (130, 0), (140, 1), (150, 1), (160, 1), (170, 1), (180, 1), (190, 1), (200, 0), (210, 1), (220, 1), (230, 0), (240, 0), (250, 1), (260, 1), (270, 1), (280, 0), (290, 0), (300, 1), (310, 1), (320, 1), (330, 1), (340, 1), (350, 0), (360, 0), (370, 1), (380, 0), (390, 0), (400, 0), (410, 0), (420, 0), (430, 1), (440, 1), (450, 1), (460, 0), (470, 0), (480, 0), (490, 1), (500, 1), (510, 0), (520, 0), (530, 1), (540, 1), (550, 1), (560, 0), (570, 1), (580, 0), (590, 0), (600, 0), (610, 1), (620, 0), (630, 0), (640, 0), (650, 0), (660, 1), (670, 1), (680, 0), (690, 0), (700, 0), (710, 0), (720, 0), (730, 0), (740, 0), (750, 0), (760, 0), (770, 0), (780, 0), (790, 0), (800, 0), (810, 0), (820, 0), (830, 1), (840, 0), (850, 0), (860, 0), (870, 0), (880, 1), (890, 0), (900, 0), (910, 1), (920, 0), (930, 0), (940, 1), (950, 0), (960, 1), (970, 0), (980, 0), (990, 0), (1000, 1), (1010, 1), (1020, 1), (1030, 1), (1040, 1), (1050, 1), (1060, 0), (1070, 1), (1080, 1), (1090, 0), (1100, 0), (1110, 0), (1120, 1), (1130, 0), (1140, 1), (1150, 0), (1160, 1), (1170, 0), (1180, 0), (1190, 1), (1200, 1), (1210, 0), (1220, 0), (1230, 0), (1240, 1), (1250, 0), (1260, 0), (1270, 1), (1280, 0), (1290, 0), (1300, 0), (1310, 0), (1320, 1), (1330, 0), (1340, 0), (1350, 1), (1360, 0), (1370, 0), (1380, 0), (1390, 0), (1400, 0), (1410, 0), (1420, 0), (1430, 1), (1440, 0), (1450, 1), (1460, 1), (1470, 0), (1480, 1), (1490, 1), (1500, 1), (1510, 0), (1520, 0), (1530, 1), (1540, 1), (1550, 0), (1560, 0), (1570, 1), (1580, 1), (1590, 0), (1600, 0), (1610, 0), (1620, 1), (1630, 0), (1640, 0), (1650, 1), (1660, 0), (1670, 1), (1680, 1), (1690, 1), (1700, 1), (1710, 1), (1720, 0), (1730, 0), (1740, 0), (1750, 0), (1760, 0), (1770, 1), (1780, 1), (1790, 0), (1800, 1), (1810, 0), (1820, 0), (1830, 1), (1840, 0), (1850, 0), (1860, 0), (1870, 0), (1880, 1), (1890, 0), (1900, 1), (1910, 1), (1920, 1), (1930, 1), (1940, 0), (1950, 0), (1960, 0), (1970, 0), (1980, 0), (1990, 1), (2000, 1), (2010, 1), (2020, 1), (2030, 1), (2040, 1), (2050, 1)]
Va0_4  a0_4  0 PWL (0n 0.0v 9.495n 0.0v 9.505n 1.8v 19.495n 1.8v 19.505n 0.0v 29.495n 0.0v 29.505n 0.0v 39.495n 0.0v 39.505n 0.0v 49.495n 0.0v 49.505n 1.8v 59.495n 1.8v 59.505n 1.8v 69.495n 1.8v 69.505n 0.0v 79.495n 0.0v 79.505n 1.8v 89.495n 1.8v 89.505n 1.8v 99.495n 1.8v 99.505n 1.8v 109.495n 1.8v 109.505n 1.8v 119.495n 1.8v 119.505n 1.8v 129.495n 1.8v 129.505n 0.0v 139.495n 0.0v 139.505n 1.8v 149.495n 1.8v 149.505n 1.8v 159.495n 1.8v 159.505n 1.8v 169.495n 1.8v 169.505n 1.8v 179.495n 1.8v 179.505n 1.8v 189.495n 1.8v 189.505n 1.8v 199.495n 1.8v 199.505n 0.0v 209.495n 0.0v 209.505n 1.8v 219.495n 1.8v 219.505n 1.8v 229.495n 1.8v 229.505n 0.0v 239.495n 0.0v 239.505n 0.0v 249.495n 0.0v 249.505n 1.8v 259.495n 1.8v 259.505n 1.8v 269.495n 1.8v 269.505n 1.8v 279.495n 1.8v 279.505n 0.0v 289.495n 0.0v 289.505n 0.0v 299.495n 0.0v 299.505n 1.8v 309.495n 1.8v 309.505n 1.8v 319.495n 1.8v 319.505n 1.8v 329.495n 1.8v 329.505n 1.8v 339.495n 1.8v 339.505n 1.8v 349.495n 1.8v 349.505n 0.0v 359.495n 0.0v 359.505n 0.0v 369.495n 0.0v 369.505n 1.8v 379.495n 1.8v 379.505n 0.0v 389.495n 0.0v 389.505n 0.0v 399.495n 0.0v 399.505n 0.0v 409.495n 0.0v 409.505n 0.0v 419.495n 0.0v 419.505n 0.0v 429.495n 0.0v 429.505n 1.8v 439.495n 1.8v 439.505n 1.8v 449.495n 1.8v 449.505n 1.8v 459.495n 1.8v 459.505n 0.0v 469.495n 0.0v 469.505n 0.0v 479.495n 0.0v 479.505n 0.0v 489.495n 0.0v 489.505n 1.8v 499.495n 1.8v 499.505n 1.8v 509.495n 1.8v 509.505n 0.0v 519.495n 0.0v 519.505n 0.0v 529.495n 0.0v 529.505n 1.8v 539.495n 1.8v 539.505n 1.8v 549.495n 1.8v 549.505n 1.8v 559.495n 1.8v 559.505n 0.0v 569.495n 0.0v 569.505n 1.8v 579.495n 1.8v 579.505n 0.0v 589.495n 0.0v 589.505n 0.0v 599.495n 0.0v 599.505n 0.0v 609.495n 0.0v 609.505n 1.8v 619.495n 1.8v 619.505n 0.0v 629.495n 0.0v 629.505n 0.0v 639.495n 0.0v 639.505n 0.0v 649.495n 0.0v 649.505n 0.0v 659.495n 0.0v 659.505n 1.8v 669.495n 1.8v 669.505n 1.8v 679.495n 1.8v 679.505n 0.0v 689.495n 0.0v 689.505n 0.0v 699.495n 0.0v 699.505n 0.0v 709.495n 0.0v 709.505n 0.0v 719.495n 0.0v 719.505n 0.0v 729.495n 0.0v 729.505n 0.0v 739.495n 0.0v 739.505n 0.0v 749.495n 0.0v 749.505n 0.0v 759.495n 0.0v 759.505n 0.0v 769.495n 0.0v 769.505n 0.0v 779.495n 0.0v 779.505n 0.0v 789.495n 0.0v 789.505n 0.0v 799.495n 0.0v 799.505n 0.0v 809.495n 0.0v 809.505n 0.0v 819.495n 0.0v 819.505n 0.0v 829.495n 0.0v 829.505n 1.8v 839.495n 1.8v 839.505n 0.0v 849.495n 0.0v 849.505n 0.0v 859.495n 0.0v 859.505n 0.0v 869.495n 0.0v 869.505n 0.0v 879.495n 0.0v 879.505n 1.8v 889.495n 1.8v 889.505n 0.0v 899.495n 0.0v 899.505n 0.0v 909.495n 0.0v 909.505n 1.8v 919.495n 1.8v 919.505n 0.0v 929.495n 0.0v 929.505n 0.0v 939.495n 0.0v 939.505n 1.8v 949.495n 1.8v 949.505n 0.0v 959.495n 0.0v 959.505n 1.8v 969.495n 1.8v 969.505n 0.0v 979.495n 0.0v 979.505n 0.0v 989.495n 0.0v 989.505n 0.0v 999.495n 0.0v 999.505n 1.8v 1009.495n 1.8v 1009.505n 1.8v 1019.495n 1.8v 1019.505n 1.8v 1029.495n 1.8v 1029.505n 1.8v 1039.495n 1.8v 1039.505n 1.8v 1049.495n 1.8v 1049.505n 1.8v 1059.495n 1.8v 1059.505n 0.0v 1069.495n 0.0v 1069.505n 1.8v 1079.495n 1.8v 1079.505n 1.8v 1089.495n 1.8v 1089.505n 0.0v 1099.495n 0.0v 1099.505n 0.0v 1109.495n 0.0v 1109.505n 0.0v 1119.495n 0.0v 1119.505n 1.8v 1129.495n 1.8v 1129.505n 0.0v 1139.495n 0.0v 1139.505n 1.8v 1149.495n 1.8v 1149.505n 0.0v 1159.495n 0.0v 1159.505n 1.8v 1169.495n 1.8v 1169.505n 0.0v 1179.495n 0.0v 1179.505n 0.0v 1189.495n 0.0v 1189.505n 1.8v 1199.495n 1.8v 1199.505n 1.8v 1209.495n 1.8v 1209.505n 0.0v 1219.495n 0.0v 1219.505n 0.0v 1229.495n 0.0v 1229.505n 0.0v 1239.495n 0.0v 1239.505n 1.8v 1249.495n 1.8v 1249.505n 0.0v 1259.495n 0.0v 1259.505n 0.0v 1269.495n 0.0v 1269.505n 1.8v 1279.495n 1.8v 1279.505n 0.0v 1289.495n 0.0v 1289.505n 0.0v 1299.495n 0.0v 1299.505n 0.0v 1309.495n 0.0v 1309.505n 0.0v 1319.495n 0.0v 1319.505n 1.8v 1329.495n 1.8v 1329.505n 0.0v 1339.495n 0.0v 1339.505n 0.0v 1349.495n 0.0v 1349.505n 1.8v 1359.495n 1.8v 1359.505n 0.0v 1369.495n 0.0v 1369.505n 0.0v 1379.495n 0.0v 1379.505n 0.0v 1389.495n 0.0v 1389.505n 0.0v 1399.495n 0.0v 1399.505n 0.0v 1409.495n 0.0v 1409.505n 0.0v 1419.495n 0.0v 1419.505n 0.0v 1429.495n 0.0v 1429.505n 1.8v 1439.495n 1.8v 1439.505n 0.0v 1449.495n 0.0v 1449.505n 1.8v 1459.495n 1.8v 1459.505n 1.8v 1469.495n 1.8v 1469.505n 0.0v 1479.495n 0.0v 1479.505n 1.8v 1489.495n 1.8v 1489.505n 1.8v 1499.495n 1.8v 1499.505n 1.8v 1509.495n 1.8v 1509.505n 0.0v 1519.495n 0.0v 1519.505n 0.0v 1529.495n 0.0v 1529.505n 1.8v 1539.495n 1.8v 1539.505n 1.8v 1549.495n 1.8v 1549.505n 0.0v 1559.495n 0.0v 1559.505n 0.0v 1569.495n 0.0v 1569.505n 1.8v 1579.495n 1.8v 1579.505n 1.8v 1589.495n 1.8v 1589.505n 0.0v 1599.495n 0.0v 1599.505n 0.0v 1609.495n 0.0v 1609.505n 0.0v 1619.495n 0.0v 1619.505n 1.8v 1629.495n 1.8v 1629.505n 0.0v 1639.495n 0.0v 1639.505n 0.0v 1649.495n 0.0v 1649.505n 1.8v 1659.495n 1.8v 1659.505n 0.0v 1669.495n 0.0v 1669.505n 1.8v 1679.495n 1.8v 1679.505n 1.8v 1689.495n 1.8v 1689.505n 1.8v 1699.495n 1.8v 1699.505n 1.8v 1709.495n 1.8v 1709.505n 1.8v 1719.495n 1.8v 1719.505n 0.0v 1729.495n 0.0v 1729.505n 0.0v 1739.495n 0.0v 1739.505n 0.0v 1749.495n 0.0v 1749.505n 0.0v 1759.495n 0.0v 1759.505n 0.0v 1769.495n 0.0v 1769.505n 1.8v 1779.495n 1.8v 1779.505n 1.8v 1789.495n 1.8v 1789.505n 0.0v 1799.495n 0.0v 1799.505n 1.8v 1809.495n 1.8v 1809.505n 0.0v 1819.495n 0.0v 1819.505n 0.0v 1829.495n 0.0v 1829.505n 1.8v 1839.495n 1.8v 1839.505n 0.0v 1849.495n 0.0v 1849.505n 0.0v 1859.495n 0.0v 1859.505n 0.0v 1869.495n 0.0v 1869.505n 0.0v 1879.495n 0.0v 1879.505n 1.8v 1889.495n 1.8v 1889.505n 0.0v 1899.495n 0.0v 1899.505n 1.8v 1909.495n 1.8v 1909.505n 1.8v 1919.495n 1.8v 1919.505n 1.8v 1929.495n 1.8v 1929.505n 1.8v 1939.495n 1.8v 1939.505n 0.0v 1949.495n 0.0v 1949.505n 0.0v 1959.495n 0.0v 1959.505n 0.0v 1969.495n 0.0v 1969.505n 0.0v 1979.495n 0.0v 1979.505n 0.0v 1989.495n 0.0v 1989.505n 1.8v 1999.495n 1.8v 1999.505n 1.8v 2009.495n 1.8v 2009.505n 1.8v 2019.495n 1.8v 2019.505n 1.8v 2029.495n 1.8v 2029.505n 1.8v 2039.495n 1.8v 2039.505n 1.8v 2049.495n 1.8v 2049.505n 1.8v )
* (time, data): [(0, 0), (10, 1), (20, 0), (30, 0), (40, 0), (50, 1), (60, 1), (70, 0), (80, 1), (90, 1), (100, 1), (110, 1), (120, 1), (130, 0), (140, 1), (150, 1), (160, 1), (170, 1), (180, 1), (190, 1), (200, 0), (210, 1), (220, 1), (230, 0), (240, 0), (250, 1), (260, 1), (270, 1), (280, 0), (290, 0), (300, 1), (310, 1), (320, 1), (330, 1), (340, 1), (350, 0), (360, 0), (370, 1), (380, 0), (390, 0), (400, 0), (410, 0), (420, 0), (430, 1), (440, 1), (450, 1), (460, 0), (470, 0), (480, 0), (490, 1), (500, 1), (510, 0), (520, 0), (530, 1), (540, 1), (550, 1), (560, 0), (570, 1), (580, 0), (590, 0), (600, 0), (610, 1), (620, 0), (630, 0), (640, 0), (650, 0), (660, 1), (670, 1), (680, 0), (690, 0), (700, 0), (710, 0), (720, 0), (730, 0), (740, 0), (750, 0), (760, 0), (770, 0), (780, 0), (790, 0), (800, 0), (810, 0), (820, 0), (830, 1), (840, 0), (850, 0), (860, 0), (870, 0), (880, 1), (890, 0), (900, 0), (910, 1), (920, 0), (930, 0), (940, 1), (950, 0), (960, 1), (970, 0), (980, 0), (990, 0), (1000, 1), (1010, 1), (1020, 1), (1030, 1), (1040, 1), (1050, 1), (1060, 0), (1070, 1), (1080, 1), (1090, 0), (1100, 0), (1110, 0), (1120, 1), (1130, 0), (1140, 1), (1150, 0), (1160, 1), (1170, 0), (1180, 0), (1190, 1), (1200, 1), (1210, 0), (1220, 0), (1230, 0), (1240, 1), (1250, 0), (1260, 0), (1270, 1), (1280, 0), (1290, 0), (1300, 0), (1310, 0), (1320, 1), (1330, 0), (1340, 0), (1350, 1), (1360, 0), (1370, 0), (1380, 0), (1390, 0), (1400, 0), (1410, 0), (1420, 0), (1430, 1), (1440, 0), (1450, 1), (1460, 1), (1470, 0), (1480, 1), (1490, 1), (1500, 1), (1510, 0), (1520, 0), (1530, 1), (1540, 1), (1550, 0), (1560, 0), (1570, 1), (1580, 1), (1590, 0), (1600, 0), (1610, 0), (1620, 1), (1630, 0), (1640, 0), (1650, 1), (1660, 0), (1670, 1), (1680, 1), (1690, 1), (1700, 1), (1710, 1), (1720, 0), (1730, 0), (1740, 0), (1750, 0), (1760, 0), (1770, 1), (1780, 1), (1790, 0), (1800, 1), (1810, 0), (1820, 0), (1830, 1), (1840, 0), (1850, 0), (1860, 0), (1870, 0), (1880, 1), (1890, 0), (1900, 1), (1910, 1), (1920, 1), (1930, 1), (1940, 0), (1950, 0), (1960, 0), (1970, 0), (1980, 0), (1990, 1), (2000, 1), (2010, 1), (2020, 1), (2030, 1), (2040, 1), (2050, 1)]
Va0_5  a0_5  0 PWL (0n 0.0v 9.495n 0.0v 9.505n 1.8v 19.495n 1.8v 19.505n 0.0v 29.495n 0.0v 29.505n 0.0v 39.495n 0.0v 39.505n 0.0v 49.495n 0.0v 49.505n 1.8v 59.495n 1.8v 59.505n 1.8v 69.495n 1.8v 69.505n 0.0v 79.495n 0.0v 79.505n 1.8v 89.495n 1.8v 89.505n 1.8v 99.495n 1.8v 99.505n 1.8v 109.495n 1.8v 109.505n 1.8v 119.495n 1.8v 119.505n 1.8v 129.495n 1.8v 129.505n 0.0v 139.495n 0.0v 139.505n 1.8v 149.495n 1.8v 149.505n 1.8v 159.495n 1.8v 159.505n 1.8v 169.495n 1.8v 169.505n 1.8v 179.495n 1.8v 179.505n 1.8v 189.495n 1.8v 189.505n 1.8v 199.495n 1.8v 199.505n 0.0v 209.495n 0.0v 209.505n 1.8v 219.495n 1.8v 219.505n 1.8v 229.495n 1.8v 229.505n 0.0v 239.495n 0.0v 239.505n 0.0v 249.495n 0.0v 249.505n 1.8v 259.495n 1.8v 259.505n 1.8v 269.495n 1.8v 269.505n 1.8v 279.495n 1.8v 279.505n 0.0v 289.495n 0.0v 289.505n 0.0v 299.495n 0.0v 299.505n 1.8v 309.495n 1.8v 309.505n 1.8v 319.495n 1.8v 319.505n 1.8v 329.495n 1.8v 329.505n 1.8v 339.495n 1.8v 339.505n 1.8v 349.495n 1.8v 349.505n 0.0v 359.495n 0.0v 359.505n 0.0v 369.495n 0.0v 369.505n 1.8v 379.495n 1.8v 379.505n 0.0v 389.495n 0.0v 389.505n 0.0v 399.495n 0.0v 399.505n 0.0v 409.495n 0.0v 409.505n 0.0v 419.495n 0.0v 419.505n 0.0v 429.495n 0.0v 429.505n 1.8v 439.495n 1.8v 439.505n 1.8v 449.495n 1.8v 449.505n 1.8v 459.495n 1.8v 459.505n 0.0v 469.495n 0.0v 469.505n 0.0v 479.495n 0.0v 479.505n 0.0v 489.495n 0.0v 489.505n 1.8v 499.495n 1.8v 499.505n 1.8v 509.495n 1.8v 509.505n 0.0v 519.495n 0.0v 519.505n 0.0v 529.495n 0.0v 529.505n 1.8v 539.495n 1.8v 539.505n 1.8v 549.495n 1.8v 549.505n 1.8v 559.495n 1.8v 559.505n 0.0v 569.495n 0.0v 569.505n 1.8v 579.495n 1.8v 579.505n 0.0v 589.495n 0.0v 589.505n 0.0v 599.495n 0.0v 599.505n 0.0v 609.495n 0.0v 609.505n 1.8v 619.495n 1.8v 619.505n 0.0v 629.495n 0.0v 629.505n 0.0v 639.495n 0.0v 639.505n 0.0v 649.495n 0.0v 649.505n 0.0v 659.495n 0.0v 659.505n 1.8v 669.495n 1.8v 669.505n 1.8v 679.495n 1.8v 679.505n 0.0v 689.495n 0.0v 689.505n 0.0v 699.495n 0.0v 699.505n 0.0v 709.495n 0.0v 709.505n 0.0v 719.495n 0.0v 719.505n 0.0v 729.495n 0.0v 729.505n 0.0v 739.495n 0.0v 739.505n 0.0v 749.495n 0.0v 749.505n 0.0v 759.495n 0.0v 759.505n 0.0v 769.495n 0.0v 769.505n 0.0v 779.495n 0.0v 779.505n 0.0v 789.495n 0.0v 789.505n 0.0v 799.495n 0.0v 799.505n 0.0v 809.495n 0.0v 809.505n 0.0v 819.495n 0.0v 819.505n 0.0v 829.495n 0.0v 829.505n 1.8v 839.495n 1.8v 839.505n 0.0v 849.495n 0.0v 849.505n 0.0v 859.495n 0.0v 859.505n 0.0v 869.495n 0.0v 869.505n 0.0v 879.495n 0.0v 879.505n 1.8v 889.495n 1.8v 889.505n 0.0v 899.495n 0.0v 899.505n 0.0v 909.495n 0.0v 909.505n 1.8v 919.495n 1.8v 919.505n 0.0v 929.495n 0.0v 929.505n 0.0v 939.495n 0.0v 939.505n 1.8v 949.495n 1.8v 949.505n 0.0v 959.495n 0.0v 959.505n 1.8v 969.495n 1.8v 969.505n 0.0v 979.495n 0.0v 979.505n 0.0v 989.495n 0.0v 989.505n 0.0v 999.495n 0.0v 999.505n 1.8v 1009.495n 1.8v 1009.505n 1.8v 1019.495n 1.8v 1019.505n 1.8v 1029.495n 1.8v 1029.505n 1.8v 1039.495n 1.8v 1039.505n 1.8v 1049.495n 1.8v 1049.505n 1.8v 1059.495n 1.8v 1059.505n 0.0v 1069.495n 0.0v 1069.505n 1.8v 1079.495n 1.8v 1079.505n 1.8v 1089.495n 1.8v 1089.505n 0.0v 1099.495n 0.0v 1099.505n 0.0v 1109.495n 0.0v 1109.505n 0.0v 1119.495n 0.0v 1119.505n 1.8v 1129.495n 1.8v 1129.505n 0.0v 1139.495n 0.0v 1139.505n 1.8v 1149.495n 1.8v 1149.505n 0.0v 1159.495n 0.0v 1159.505n 1.8v 1169.495n 1.8v 1169.505n 0.0v 1179.495n 0.0v 1179.505n 0.0v 1189.495n 0.0v 1189.505n 1.8v 1199.495n 1.8v 1199.505n 1.8v 1209.495n 1.8v 1209.505n 0.0v 1219.495n 0.0v 1219.505n 0.0v 1229.495n 0.0v 1229.505n 0.0v 1239.495n 0.0v 1239.505n 1.8v 1249.495n 1.8v 1249.505n 0.0v 1259.495n 0.0v 1259.505n 0.0v 1269.495n 0.0v 1269.505n 1.8v 1279.495n 1.8v 1279.505n 0.0v 1289.495n 0.0v 1289.505n 0.0v 1299.495n 0.0v 1299.505n 0.0v 1309.495n 0.0v 1309.505n 0.0v 1319.495n 0.0v 1319.505n 1.8v 1329.495n 1.8v 1329.505n 0.0v 1339.495n 0.0v 1339.505n 0.0v 1349.495n 0.0v 1349.505n 1.8v 1359.495n 1.8v 1359.505n 0.0v 1369.495n 0.0v 1369.505n 0.0v 1379.495n 0.0v 1379.505n 0.0v 1389.495n 0.0v 1389.505n 0.0v 1399.495n 0.0v 1399.505n 0.0v 1409.495n 0.0v 1409.505n 0.0v 1419.495n 0.0v 1419.505n 0.0v 1429.495n 0.0v 1429.505n 1.8v 1439.495n 1.8v 1439.505n 0.0v 1449.495n 0.0v 1449.505n 1.8v 1459.495n 1.8v 1459.505n 1.8v 1469.495n 1.8v 1469.505n 0.0v 1479.495n 0.0v 1479.505n 1.8v 1489.495n 1.8v 1489.505n 1.8v 1499.495n 1.8v 1499.505n 1.8v 1509.495n 1.8v 1509.505n 0.0v 1519.495n 0.0v 1519.505n 0.0v 1529.495n 0.0v 1529.505n 1.8v 1539.495n 1.8v 1539.505n 1.8v 1549.495n 1.8v 1549.505n 0.0v 1559.495n 0.0v 1559.505n 0.0v 1569.495n 0.0v 1569.505n 1.8v 1579.495n 1.8v 1579.505n 1.8v 1589.495n 1.8v 1589.505n 0.0v 1599.495n 0.0v 1599.505n 0.0v 1609.495n 0.0v 1609.505n 0.0v 1619.495n 0.0v 1619.505n 1.8v 1629.495n 1.8v 1629.505n 0.0v 1639.495n 0.0v 1639.505n 0.0v 1649.495n 0.0v 1649.505n 1.8v 1659.495n 1.8v 1659.505n 0.0v 1669.495n 0.0v 1669.505n 1.8v 1679.495n 1.8v 1679.505n 1.8v 1689.495n 1.8v 1689.505n 1.8v 1699.495n 1.8v 1699.505n 1.8v 1709.495n 1.8v 1709.505n 1.8v 1719.495n 1.8v 1719.505n 0.0v 1729.495n 0.0v 1729.505n 0.0v 1739.495n 0.0v 1739.505n 0.0v 1749.495n 0.0v 1749.505n 0.0v 1759.495n 0.0v 1759.505n 0.0v 1769.495n 0.0v 1769.505n 1.8v 1779.495n 1.8v 1779.505n 1.8v 1789.495n 1.8v 1789.505n 0.0v 1799.495n 0.0v 1799.505n 1.8v 1809.495n 1.8v 1809.505n 0.0v 1819.495n 0.0v 1819.505n 0.0v 1829.495n 0.0v 1829.505n 1.8v 1839.495n 1.8v 1839.505n 0.0v 1849.495n 0.0v 1849.505n 0.0v 1859.495n 0.0v 1859.505n 0.0v 1869.495n 0.0v 1869.505n 0.0v 1879.495n 0.0v 1879.505n 1.8v 1889.495n 1.8v 1889.505n 0.0v 1899.495n 0.0v 1899.505n 1.8v 1909.495n 1.8v 1909.505n 1.8v 1919.495n 1.8v 1919.505n 1.8v 1929.495n 1.8v 1929.505n 1.8v 1939.495n 1.8v 1939.505n 0.0v 1949.495n 0.0v 1949.505n 0.0v 1959.495n 0.0v 1959.505n 0.0v 1969.495n 0.0v 1969.505n 0.0v 1979.495n 0.0v 1979.505n 0.0v 1989.495n 0.0v 1989.505n 1.8v 1999.495n 1.8v 1999.505n 1.8v 2009.495n 1.8v 2009.505n 1.8v 2019.495n 1.8v 2019.505n 1.8v 2029.495n 1.8v 2029.505n 1.8v 2039.495n 1.8v 2039.505n 1.8v 2049.495n 1.8v 2049.505n 1.8v )
* (time, data): [(0, 0), (10, 1), (20, 0), (30, 0), (40, 0), (50, 1), (60, 1), (70, 0), (80, 1), (90, 1), (100, 1), (110, 1), (120, 1), (130, 0), (140, 1), (150, 1), (160, 1), (170, 1), (180, 1), (190, 1), (200, 0), (210, 1), (220, 1), (230, 0), (240, 0), (250, 1), (260, 1), (270, 1), (280, 0), (290, 0), (300, 1), (310, 1), (320, 1), (330, 1), (340, 1), (350, 0), (360, 0), (370, 1), (380, 0), (390, 0), (400, 0), (410, 0), (420, 0), (430, 1), (440, 1), (450, 1), (460, 0), (470, 0), (480, 0), (490, 1), (500, 1), (510, 0), (520, 0), (530, 1), (540, 1), (550, 1), (560, 0), (570, 1), (580, 0), (590, 0), (600, 0), (610, 1), (620, 0), (630, 0), (640, 0), (650, 0), (660, 1), (670, 1), (680, 0), (690, 0), (700, 0), (710, 0), (720, 0), (730, 0), (740, 0), (750, 0), (760, 0), (770, 0), (780, 0), (790, 0), (800, 0), (810, 0), (820, 0), (830, 1), (840, 0), (850, 0), (860, 0), (870, 0), (880, 1), (890, 0), (900, 0), (910, 1), (920, 0), (930, 0), (940, 1), (950, 0), (960, 1), (970, 0), (980, 0), (990, 0), (1000, 1), (1010, 1), (1020, 1), (1030, 1), (1040, 1), (1050, 1), (1060, 0), (1070, 1), (1080, 1), (1090, 0), (1100, 0), (1110, 0), (1120, 1), (1130, 0), (1140, 1), (1150, 0), (1160, 1), (1170, 0), (1180, 0), (1190, 1), (1200, 1), (1210, 0), (1220, 0), (1230, 0), (1240, 1), (1250, 0), (1260, 0), (1270, 1), (1280, 0), (1290, 0), (1300, 0), (1310, 0), (1320, 1), (1330, 0), (1340, 0), (1350, 1), (1360, 0), (1370, 0), (1380, 0), (1390, 0), (1400, 0), (1410, 0), (1420, 0), (1430, 1), (1440, 0), (1450, 1), (1460, 1), (1470, 0), (1480, 1), (1490, 1), (1500, 1), (1510, 0), (1520, 0), (1530, 1), (1540, 1), (1550, 0), (1560, 0), (1570, 1), (1580, 1), (1590, 0), (1600, 0), (1610, 0), (1620, 1), (1630, 0), (1640, 0), (1650, 1), (1660, 0), (1670, 1), (1680, 1), (1690, 1), (1700, 1), (1710, 1), (1720, 0), (1730, 0), (1740, 0), (1750, 0), (1760, 0), (1770, 1), (1780, 1), (1790, 0), (1800, 1), (1810, 0), (1820, 0), (1830, 1), (1840, 0), (1850, 0), (1860, 0), (1870, 0), (1880, 1), (1890, 0), (1900, 1), (1910, 1), (1920, 1), (1930, 1), (1940, 0), (1950, 0), (1960, 0), (1970, 0), (1980, 0), (1990, 1), (2000, 1), (2010, 1), (2020, 1), (2030, 1), (2040, 1), (2050, 1)]
Va0_6  a0_6  0 PWL (0n 0.0v 9.495n 0.0v 9.505n 1.8v 19.495n 1.8v 19.505n 0.0v 29.495n 0.0v 29.505n 0.0v 39.495n 0.0v 39.505n 0.0v 49.495n 0.0v 49.505n 1.8v 59.495n 1.8v 59.505n 1.8v 69.495n 1.8v 69.505n 0.0v 79.495n 0.0v 79.505n 1.8v 89.495n 1.8v 89.505n 1.8v 99.495n 1.8v 99.505n 1.8v 109.495n 1.8v 109.505n 1.8v 119.495n 1.8v 119.505n 1.8v 129.495n 1.8v 129.505n 0.0v 139.495n 0.0v 139.505n 1.8v 149.495n 1.8v 149.505n 1.8v 159.495n 1.8v 159.505n 1.8v 169.495n 1.8v 169.505n 1.8v 179.495n 1.8v 179.505n 1.8v 189.495n 1.8v 189.505n 1.8v 199.495n 1.8v 199.505n 0.0v 209.495n 0.0v 209.505n 1.8v 219.495n 1.8v 219.505n 1.8v 229.495n 1.8v 229.505n 0.0v 239.495n 0.0v 239.505n 0.0v 249.495n 0.0v 249.505n 1.8v 259.495n 1.8v 259.505n 1.8v 269.495n 1.8v 269.505n 1.8v 279.495n 1.8v 279.505n 0.0v 289.495n 0.0v 289.505n 0.0v 299.495n 0.0v 299.505n 1.8v 309.495n 1.8v 309.505n 1.8v 319.495n 1.8v 319.505n 1.8v 329.495n 1.8v 329.505n 1.8v 339.495n 1.8v 339.505n 1.8v 349.495n 1.8v 349.505n 0.0v 359.495n 0.0v 359.505n 0.0v 369.495n 0.0v 369.505n 1.8v 379.495n 1.8v 379.505n 0.0v 389.495n 0.0v 389.505n 0.0v 399.495n 0.0v 399.505n 0.0v 409.495n 0.0v 409.505n 0.0v 419.495n 0.0v 419.505n 0.0v 429.495n 0.0v 429.505n 1.8v 439.495n 1.8v 439.505n 1.8v 449.495n 1.8v 449.505n 1.8v 459.495n 1.8v 459.505n 0.0v 469.495n 0.0v 469.505n 0.0v 479.495n 0.0v 479.505n 0.0v 489.495n 0.0v 489.505n 1.8v 499.495n 1.8v 499.505n 1.8v 509.495n 1.8v 509.505n 0.0v 519.495n 0.0v 519.505n 0.0v 529.495n 0.0v 529.505n 1.8v 539.495n 1.8v 539.505n 1.8v 549.495n 1.8v 549.505n 1.8v 559.495n 1.8v 559.505n 0.0v 569.495n 0.0v 569.505n 1.8v 579.495n 1.8v 579.505n 0.0v 589.495n 0.0v 589.505n 0.0v 599.495n 0.0v 599.505n 0.0v 609.495n 0.0v 609.505n 1.8v 619.495n 1.8v 619.505n 0.0v 629.495n 0.0v 629.505n 0.0v 639.495n 0.0v 639.505n 0.0v 649.495n 0.0v 649.505n 0.0v 659.495n 0.0v 659.505n 1.8v 669.495n 1.8v 669.505n 1.8v 679.495n 1.8v 679.505n 0.0v 689.495n 0.0v 689.505n 0.0v 699.495n 0.0v 699.505n 0.0v 709.495n 0.0v 709.505n 0.0v 719.495n 0.0v 719.505n 0.0v 729.495n 0.0v 729.505n 0.0v 739.495n 0.0v 739.505n 0.0v 749.495n 0.0v 749.505n 0.0v 759.495n 0.0v 759.505n 0.0v 769.495n 0.0v 769.505n 0.0v 779.495n 0.0v 779.505n 0.0v 789.495n 0.0v 789.505n 0.0v 799.495n 0.0v 799.505n 0.0v 809.495n 0.0v 809.505n 0.0v 819.495n 0.0v 819.505n 0.0v 829.495n 0.0v 829.505n 1.8v 839.495n 1.8v 839.505n 0.0v 849.495n 0.0v 849.505n 0.0v 859.495n 0.0v 859.505n 0.0v 869.495n 0.0v 869.505n 0.0v 879.495n 0.0v 879.505n 1.8v 889.495n 1.8v 889.505n 0.0v 899.495n 0.0v 899.505n 0.0v 909.495n 0.0v 909.505n 1.8v 919.495n 1.8v 919.505n 0.0v 929.495n 0.0v 929.505n 0.0v 939.495n 0.0v 939.505n 1.8v 949.495n 1.8v 949.505n 0.0v 959.495n 0.0v 959.505n 1.8v 969.495n 1.8v 969.505n 0.0v 979.495n 0.0v 979.505n 0.0v 989.495n 0.0v 989.505n 0.0v 999.495n 0.0v 999.505n 1.8v 1009.495n 1.8v 1009.505n 1.8v 1019.495n 1.8v 1019.505n 1.8v 1029.495n 1.8v 1029.505n 1.8v 1039.495n 1.8v 1039.505n 1.8v 1049.495n 1.8v 1049.505n 1.8v 1059.495n 1.8v 1059.505n 0.0v 1069.495n 0.0v 1069.505n 1.8v 1079.495n 1.8v 1079.505n 1.8v 1089.495n 1.8v 1089.505n 0.0v 1099.495n 0.0v 1099.505n 0.0v 1109.495n 0.0v 1109.505n 0.0v 1119.495n 0.0v 1119.505n 1.8v 1129.495n 1.8v 1129.505n 0.0v 1139.495n 0.0v 1139.505n 1.8v 1149.495n 1.8v 1149.505n 0.0v 1159.495n 0.0v 1159.505n 1.8v 1169.495n 1.8v 1169.505n 0.0v 1179.495n 0.0v 1179.505n 0.0v 1189.495n 0.0v 1189.505n 1.8v 1199.495n 1.8v 1199.505n 1.8v 1209.495n 1.8v 1209.505n 0.0v 1219.495n 0.0v 1219.505n 0.0v 1229.495n 0.0v 1229.505n 0.0v 1239.495n 0.0v 1239.505n 1.8v 1249.495n 1.8v 1249.505n 0.0v 1259.495n 0.0v 1259.505n 0.0v 1269.495n 0.0v 1269.505n 1.8v 1279.495n 1.8v 1279.505n 0.0v 1289.495n 0.0v 1289.505n 0.0v 1299.495n 0.0v 1299.505n 0.0v 1309.495n 0.0v 1309.505n 0.0v 1319.495n 0.0v 1319.505n 1.8v 1329.495n 1.8v 1329.505n 0.0v 1339.495n 0.0v 1339.505n 0.0v 1349.495n 0.0v 1349.505n 1.8v 1359.495n 1.8v 1359.505n 0.0v 1369.495n 0.0v 1369.505n 0.0v 1379.495n 0.0v 1379.505n 0.0v 1389.495n 0.0v 1389.505n 0.0v 1399.495n 0.0v 1399.505n 0.0v 1409.495n 0.0v 1409.505n 0.0v 1419.495n 0.0v 1419.505n 0.0v 1429.495n 0.0v 1429.505n 1.8v 1439.495n 1.8v 1439.505n 0.0v 1449.495n 0.0v 1449.505n 1.8v 1459.495n 1.8v 1459.505n 1.8v 1469.495n 1.8v 1469.505n 0.0v 1479.495n 0.0v 1479.505n 1.8v 1489.495n 1.8v 1489.505n 1.8v 1499.495n 1.8v 1499.505n 1.8v 1509.495n 1.8v 1509.505n 0.0v 1519.495n 0.0v 1519.505n 0.0v 1529.495n 0.0v 1529.505n 1.8v 1539.495n 1.8v 1539.505n 1.8v 1549.495n 1.8v 1549.505n 0.0v 1559.495n 0.0v 1559.505n 0.0v 1569.495n 0.0v 1569.505n 1.8v 1579.495n 1.8v 1579.505n 1.8v 1589.495n 1.8v 1589.505n 0.0v 1599.495n 0.0v 1599.505n 0.0v 1609.495n 0.0v 1609.505n 0.0v 1619.495n 0.0v 1619.505n 1.8v 1629.495n 1.8v 1629.505n 0.0v 1639.495n 0.0v 1639.505n 0.0v 1649.495n 0.0v 1649.505n 1.8v 1659.495n 1.8v 1659.505n 0.0v 1669.495n 0.0v 1669.505n 1.8v 1679.495n 1.8v 1679.505n 1.8v 1689.495n 1.8v 1689.505n 1.8v 1699.495n 1.8v 1699.505n 1.8v 1709.495n 1.8v 1709.505n 1.8v 1719.495n 1.8v 1719.505n 0.0v 1729.495n 0.0v 1729.505n 0.0v 1739.495n 0.0v 1739.505n 0.0v 1749.495n 0.0v 1749.505n 0.0v 1759.495n 0.0v 1759.505n 0.0v 1769.495n 0.0v 1769.505n 1.8v 1779.495n 1.8v 1779.505n 1.8v 1789.495n 1.8v 1789.505n 0.0v 1799.495n 0.0v 1799.505n 1.8v 1809.495n 1.8v 1809.505n 0.0v 1819.495n 0.0v 1819.505n 0.0v 1829.495n 0.0v 1829.505n 1.8v 1839.495n 1.8v 1839.505n 0.0v 1849.495n 0.0v 1849.505n 0.0v 1859.495n 0.0v 1859.505n 0.0v 1869.495n 0.0v 1869.505n 0.0v 1879.495n 0.0v 1879.505n 1.8v 1889.495n 1.8v 1889.505n 0.0v 1899.495n 0.0v 1899.505n 1.8v 1909.495n 1.8v 1909.505n 1.8v 1919.495n 1.8v 1919.505n 1.8v 1929.495n 1.8v 1929.505n 1.8v 1939.495n 1.8v 1939.505n 0.0v 1949.495n 0.0v 1949.505n 0.0v 1959.495n 0.0v 1959.505n 0.0v 1969.495n 0.0v 1969.505n 0.0v 1979.495n 0.0v 1979.505n 0.0v 1989.495n 0.0v 1989.505n 1.8v 1999.495n 1.8v 1999.505n 1.8v 2009.495n 1.8v 2009.505n 1.8v 2019.495n 1.8v 2019.505n 1.8v 2029.495n 1.8v 2029.505n 1.8v 2039.495n 1.8v 2039.505n 1.8v 2049.495n 1.8v 2049.505n 1.8v )
* (time, data): [(0, 0), (10, 1), (20, 0), (30, 0), (40, 0), (50, 1), (60, 1), (70, 0), (80, 1), (90, 1), (100, 1), (110, 1), (120, 1), (130, 0), (140, 1), (150, 1), (160, 1), (170, 1), (180, 1), (190, 1), (200, 0), (210, 1), (220, 1), (230, 0), (240, 0), (250, 1), (260, 1), (270, 1), (280, 0), (290, 0), (300, 1), (310, 1), (320, 1), (330, 1), (340, 1), (350, 0), (360, 0), (370, 1), (380, 0), (390, 0), (400, 0), (410, 0), (420, 0), (430, 1), (440, 1), (450, 1), (460, 0), (470, 0), (480, 0), (490, 1), (500, 1), (510, 0), (520, 0), (530, 1), (540, 1), (550, 1), (560, 0), (570, 1), (580, 0), (590, 0), (600, 0), (610, 1), (620, 0), (630, 0), (640, 0), (650, 0), (660, 1), (670, 1), (680, 0), (690, 0), (700, 0), (710, 0), (720, 0), (730, 0), (740, 0), (750, 0), (760, 0), (770, 0), (780, 0), (790, 0), (800, 0), (810, 0), (820, 0), (830, 1), (840, 0), (850, 0), (860, 0), (870, 0), (880, 1), (890, 0), (900, 0), (910, 1), (920, 0), (930, 0), (940, 1), (950, 0), (960, 1), (970, 0), (980, 0), (990, 0), (1000, 1), (1010, 1), (1020, 1), (1030, 1), (1040, 1), (1050, 1), (1060, 0), (1070, 1), (1080, 1), (1090, 0), (1100, 0), (1110, 0), (1120, 1), (1130, 0), (1140, 1), (1150, 0), (1160, 1), (1170, 0), (1180, 0), (1190, 1), (1200, 1), (1210, 0), (1220, 0), (1230, 0), (1240, 1), (1250, 0), (1260, 0), (1270, 1), (1280, 0), (1290, 0), (1300, 0), (1310, 0), (1320, 1), (1330, 0), (1340, 0), (1350, 1), (1360, 0), (1370, 0), (1380, 0), (1390, 0), (1400, 0), (1410, 0), (1420, 0), (1430, 1), (1440, 0), (1450, 1), (1460, 1), (1470, 0), (1480, 1), (1490, 1), (1500, 1), (1510, 0), (1520, 0), (1530, 1), (1540, 1), (1550, 0), (1560, 0), (1570, 1), (1580, 1), (1590, 0), (1600, 0), (1610, 0), (1620, 1), (1630, 0), (1640, 0), (1650, 1), (1660, 0), (1670, 1), (1680, 1), (1690, 1), (1700, 1), (1710, 1), (1720, 0), (1730, 0), (1740, 0), (1750, 0), (1760, 0), (1770, 1), (1780, 1), (1790, 0), (1800, 1), (1810, 0), (1820, 0), (1830, 1), (1840, 0), (1850, 0), (1860, 0), (1870, 0), (1880, 1), (1890, 0), (1900, 1), (1910, 1), (1920, 1), (1930, 1), (1940, 0), (1950, 0), (1960, 0), (1970, 0), (1980, 0), (1990, 1), (2000, 1), (2010, 1), (2020, 1), (2030, 1), (2040, 1), (2050, 1)]
Va0_7  a0_7  0 PWL (0n 0.0v 9.495n 0.0v 9.505n 1.8v 19.495n 1.8v 19.505n 0.0v 29.495n 0.0v 29.505n 0.0v 39.495n 0.0v 39.505n 0.0v 49.495n 0.0v 49.505n 1.8v 59.495n 1.8v 59.505n 1.8v 69.495n 1.8v 69.505n 0.0v 79.495n 0.0v 79.505n 1.8v 89.495n 1.8v 89.505n 1.8v 99.495n 1.8v 99.505n 1.8v 109.495n 1.8v 109.505n 1.8v 119.495n 1.8v 119.505n 1.8v 129.495n 1.8v 129.505n 0.0v 139.495n 0.0v 139.505n 1.8v 149.495n 1.8v 149.505n 1.8v 159.495n 1.8v 159.505n 1.8v 169.495n 1.8v 169.505n 1.8v 179.495n 1.8v 179.505n 1.8v 189.495n 1.8v 189.505n 1.8v 199.495n 1.8v 199.505n 0.0v 209.495n 0.0v 209.505n 1.8v 219.495n 1.8v 219.505n 1.8v 229.495n 1.8v 229.505n 0.0v 239.495n 0.0v 239.505n 0.0v 249.495n 0.0v 249.505n 1.8v 259.495n 1.8v 259.505n 1.8v 269.495n 1.8v 269.505n 1.8v 279.495n 1.8v 279.505n 0.0v 289.495n 0.0v 289.505n 0.0v 299.495n 0.0v 299.505n 1.8v 309.495n 1.8v 309.505n 1.8v 319.495n 1.8v 319.505n 1.8v 329.495n 1.8v 329.505n 1.8v 339.495n 1.8v 339.505n 1.8v 349.495n 1.8v 349.505n 0.0v 359.495n 0.0v 359.505n 0.0v 369.495n 0.0v 369.505n 1.8v 379.495n 1.8v 379.505n 0.0v 389.495n 0.0v 389.505n 0.0v 399.495n 0.0v 399.505n 0.0v 409.495n 0.0v 409.505n 0.0v 419.495n 0.0v 419.505n 0.0v 429.495n 0.0v 429.505n 1.8v 439.495n 1.8v 439.505n 1.8v 449.495n 1.8v 449.505n 1.8v 459.495n 1.8v 459.505n 0.0v 469.495n 0.0v 469.505n 0.0v 479.495n 0.0v 479.505n 0.0v 489.495n 0.0v 489.505n 1.8v 499.495n 1.8v 499.505n 1.8v 509.495n 1.8v 509.505n 0.0v 519.495n 0.0v 519.505n 0.0v 529.495n 0.0v 529.505n 1.8v 539.495n 1.8v 539.505n 1.8v 549.495n 1.8v 549.505n 1.8v 559.495n 1.8v 559.505n 0.0v 569.495n 0.0v 569.505n 1.8v 579.495n 1.8v 579.505n 0.0v 589.495n 0.0v 589.505n 0.0v 599.495n 0.0v 599.505n 0.0v 609.495n 0.0v 609.505n 1.8v 619.495n 1.8v 619.505n 0.0v 629.495n 0.0v 629.505n 0.0v 639.495n 0.0v 639.505n 0.0v 649.495n 0.0v 649.505n 0.0v 659.495n 0.0v 659.505n 1.8v 669.495n 1.8v 669.505n 1.8v 679.495n 1.8v 679.505n 0.0v 689.495n 0.0v 689.505n 0.0v 699.495n 0.0v 699.505n 0.0v 709.495n 0.0v 709.505n 0.0v 719.495n 0.0v 719.505n 0.0v 729.495n 0.0v 729.505n 0.0v 739.495n 0.0v 739.505n 0.0v 749.495n 0.0v 749.505n 0.0v 759.495n 0.0v 759.505n 0.0v 769.495n 0.0v 769.505n 0.0v 779.495n 0.0v 779.505n 0.0v 789.495n 0.0v 789.505n 0.0v 799.495n 0.0v 799.505n 0.0v 809.495n 0.0v 809.505n 0.0v 819.495n 0.0v 819.505n 0.0v 829.495n 0.0v 829.505n 1.8v 839.495n 1.8v 839.505n 0.0v 849.495n 0.0v 849.505n 0.0v 859.495n 0.0v 859.505n 0.0v 869.495n 0.0v 869.505n 0.0v 879.495n 0.0v 879.505n 1.8v 889.495n 1.8v 889.505n 0.0v 899.495n 0.0v 899.505n 0.0v 909.495n 0.0v 909.505n 1.8v 919.495n 1.8v 919.505n 0.0v 929.495n 0.0v 929.505n 0.0v 939.495n 0.0v 939.505n 1.8v 949.495n 1.8v 949.505n 0.0v 959.495n 0.0v 959.505n 1.8v 969.495n 1.8v 969.505n 0.0v 979.495n 0.0v 979.505n 0.0v 989.495n 0.0v 989.505n 0.0v 999.495n 0.0v 999.505n 1.8v 1009.495n 1.8v 1009.505n 1.8v 1019.495n 1.8v 1019.505n 1.8v 1029.495n 1.8v 1029.505n 1.8v 1039.495n 1.8v 1039.505n 1.8v 1049.495n 1.8v 1049.505n 1.8v 1059.495n 1.8v 1059.505n 0.0v 1069.495n 0.0v 1069.505n 1.8v 1079.495n 1.8v 1079.505n 1.8v 1089.495n 1.8v 1089.505n 0.0v 1099.495n 0.0v 1099.505n 0.0v 1109.495n 0.0v 1109.505n 0.0v 1119.495n 0.0v 1119.505n 1.8v 1129.495n 1.8v 1129.505n 0.0v 1139.495n 0.0v 1139.505n 1.8v 1149.495n 1.8v 1149.505n 0.0v 1159.495n 0.0v 1159.505n 1.8v 1169.495n 1.8v 1169.505n 0.0v 1179.495n 0.0v 1179.505n 0.0v 1189.495n 0.0v 1189.505n 1.8v 1199.495n 1.8v 1199.505n 1.8v 1209.495n 1.8v 1209.505n 0.0v 1219.495n 0.0v 1219.505n 0.0v 1229.495n 0.0v 1229.505n 0.0v 1239.495n 0.0v 1239.505n 1.8v 1249.495n 1.8v 1249.505n 0.0v 1259.495n 0.0v 1259.505n 0.0v 1269.495n 0.0v 1269.505n 1.8v 1279.495n 1.8v 1279.505n 0.0v 1289.495n 0.0v 1289.505n 0.0v 1299.495n 0.0v 1299.505n 0.0v 1309.495n 0.0v 1309.505n 0.0v 1319.495n 0.0v 1319.505n 1.8v 1329.495n 1.8v 1329.505n 0.0v 1339.495n 0.0v 1339.505n 0.0v 1349.495n 0.0v 1349.505n 1.8v 1359.495n 1.8v 1359.505n 0.0v 1369.495n 0.0v 1369.505n 0.0v 1379.495n 0.0v 1379.505n 0.0v 1389.495n 0.0v 1389.505n 0.0v 1399.495n 0.0v 1399.505n 0.0v 1409.495n 0.0v 1409.505n 0.0v 1419.495n 0.0v 1419.505n 0.0v 1429.495n 0.0v 1429.505n 1.8v 1439.495n 1.8v 1439.505n 0.0v 1449.495n 0.0v 1449.505n 1.8v 1459.495n 1.8v 1459.505n 1.8v 1469.495n 1.8v 1469.505n 0.0v 1479.495n 0.0v 1479.505n 1.8v 1489.495n 1.8v 1489.505n 1.8v 1499.495n 1.8v 1499.505n 1.8v 1509.495n 1.8v 1509.505n 0.0v 1519.495n 0.0v 1519.505n 0.0v 1529.495n 0.0v 1529.505n 1.8v 1539.495n 1.8v 1539.505n 1.8v 1549.495n 1.8v 1549.505n 0.0v 1559.495n 0.0v 1559.505n 0.0v 1569.495n 0.0v 1569.505n 1.8v 1579.495n 1.8v 1579.505n 1.8v 1589.495n 1.8v 1589.505n 0.0v 1599.495n 0.0v 1599.505n 0.0v 1609.495n 0.0v 1609.505n 0.0v 1619.495n 0.0v 1619.505n 1.8v 1629.495n 1.8v 1629.505n 0.0v 1639.495n 0.0v 1639.505n 0.0v 1649.495n 0.0v 1649.505n 1.8v 1659.495n 1.8v 1659.505n 0.0v 1669.495n 0.0v 1669.505n 1.8v 1679.495n 1.8v 1679.505n 1.8v 1689.495n 1.8v 1689.505n 1.8v 1699.495n 1.8v 1699.505n 1.8v 1709.495n 1.8v 1709.505n 1.8v 1719.495n 1.8v 1719.505n 0.0v 1729.495n 0.0v 1729.505n 0.0v 1739.495n 0.0v 1739.505n 0.0v 1749.495n 0.0v 1749.505n 0.0v 1759.495n 0.0v 1759.505n 0.0v 1769.495n 0.0v 1769.505n 1.8v 1779.495n 1.8v 1779.505n 1.8v 1789.495n 1.8v 1789.505n 0.0v 1799.495n 0.0v 1799.505n 1.8v 1809.495n 1.8v 1809.505n 0.0v 1819.495n 0.0v 1819.505n 0.0v 1829.495n 0.0v 1829.505n 1.8v 1839.495n 1.8v 1839.505n 0.0v 1849.495n 0.0v 1849.505n 0.0v 1859.495n 0.0v 1859.505n 0.0v 1869.495n 0.0v 1869.505n 0.0v 1879.495n 0.0v 1879.505n 1.8v 1889.495n 1.8v 1889.505n 0.0v 1899.495n 0.0v 1899.505n 1.8v 1909.495n 1.8v 1909.505n 1.8v 1919.495n 1.8v 1919.505n 1.8v 1929.495n 1.8v 1929.505n 1.8v 1939.495n 1.8v 1939.505n 0.0v 1949.495n 0.0v 1949.505n 0.0v 1959.495n 0.0v 1959.505n 0.0v 1969.495n 0.0v 1969.505n 0.0v 1979.495n 0.0v 1979.505n 0.0v 1989.495n 0.0v 1989.505n 1.8v 1999.495n 1.8v 1999.505n 1.8v 2009.495n 1.8v 2009.505n 1.8v 2019.495n 1.8v 2019.505n 1.8v 2029.495n 1.8v 2029.505n 1.8v 2039.495n 1.8v 2039.505n 1.8v 2049.495n 1.8v 2049.505n 1.8v )
* (time, data): [(0, 0), (10, 1), (20, 0), (30, 0), (40, 0), (50, 1), (60, 1), (70, 0), (80, 1), (90, 1), (100, 1), (110, 1), (120, 1), (130, 0), (140, 1), (150, 1), (160, 1), (170, 1), (180, 1), (190, 1), (200, 0), (210, 1), (220, 1), (230, 0), (240, 0), (250, 1), (260, 1), (270, 1), (280, 0), (290, 0), (300, 1), (310, 1), (320, 1), (330, 1), (340, 1), (350, 0), (360, 0), (370, 1), (380, 0), (390, 0), (400, 0), (410, 0), (420, 0), (430, 1), (440, 1), (450, 1), (460, 0), (470, 0), (480, 0), (490, 1), (500, 1), (510, 0), (520, 0), (530, 1), (540, 1), (550, 1), (560, 0), (570, 1), (580, 0), (590, 0), (600, 0), (610, 1), (620, 0), (630, 0), (640, 0), (650, 0), (660, 1), (670, 1), (680, 0), (690, 0), (700, 0), (710, 0), (720, 0), (730, 0), (740, 0), (750, 0), (760, 0), (770, 0), (780, 0), (790, 0), (800, 0), (810, 0), (820, 0), (830, 1), (840, 0), (850, 0), (860, 0), (870, 0), (880, 1), (890, 0), (900, 0), (910, 1), (920, 0), (930, 0), (940, 1), (950, 0), (960, 1), (970, 0), (980, 0), (990, 0), (1000, 1), (1010, 1), (1020, 1), (1030, 1), (1040, 1), (1050, 1), (1060, 0), (1070, 1), (1080, 1), (1090, 0), (1100, 0), (1110, 0), (1120, 1), (1130, 0), (1140, 1), (1150, 0), (1160, 1), (1170, 0), (1180, 0), (1190, 1), (1200, 1), (1210, 0), (1220, 0), (1230, 0), (1240, 1), (1250, 0), (1260, 0), (1270, 1), (1280, 0), (1290, 0), (1300, 0), (1310, 0), (1320, 1), (1330, 0), (1340, 0), (1350, 1), (1360, 0), (1370, 0), (1380, 0), (1390, 0), (1400, 0), (1410, 0), (1420, 0), (1430, 1), (1440, 0), (1450, 1), (1460, 1), (1470, 0), (1480, 1), (1490, 1), (1500, 1), (1510, 0), (1520, 0), (1530, 1), (1540, 1), (1550, 0), (1560, 0), (1570, 1), (1580, 1), (1590, 0), (1600, 0), (1610, 0), (1620, 1), (1630, 0), (1640, 0), (1650, 1), (1660, 0), (1670, 1), (1680, 1), (1690, 1), (1700, 1), (1710, 1), (1720, 0), (1730, 0), (1740, 0), (1750, 0), (1760, 0), (1770, 1), (1780, 1), (1790, 0), (1800, 1), (1810, 0), (1820, 0), (1830, 1), (1840, 0), (1850, 0), (1860, 0), (1870, 0), (1880, 1), (1890, 0), (1900, 1), (1910, 1), (1920, 1), (1930, 1), (1940, 0), (1950, 0), (1960, 0), (1970, 0), (1980, 0), (1990, 1), (2000, 1), (2010, 1), (2020, 1), (2030, 1), (2040, 1), (2050, 1)]
Va0_8  a0_8  0 PWL (0n 0.0v 9.495n 0.0v 9.505n 1.8v 19.495n 1.8v 19.505n 0.0v 29.495n 0.0v 29.505n 0.0v 39.495n 0.0v 39.505n 0.0v 49.495n 0.0v 49.505n 1.8v 59.495n 1.8v 59.505n 1.8v 69.495n 1.8v 69.505n 0.0v 79.495n 0.0v 79.505n 1.8v 89.495n 1.8v 89.505n 1.8v 99.495n 1.8v 99.505n 1.8v 109.495n 1.8v 109.505n 1.8v 119.495n 1.8v 119.505n 1.8v 129.495n 1.8v 129.505n 0.0v 139.495n 0.0v 139.505n 1.8v 149.495n 1.8v 149.505n 1.8v 159.495n 1.8v 159.505n 1.8v 169.495n 1.8v 169.505n 1.8v 179.495n 1.8v 179.505n 1.8v 189.495n 1.8v 189.505n 1.8v 199.495n 1.8v 199.505n 0.0v 209.495n 0.0v 209.505n 1.8v 219.495n 1.8v 219.505n 1.8v 229.495n 1.8v 229.505n 0.0v 239.495n 0.0v 239.505n 0.0v 249.495n 0.0v 249.505n 1.8v 259.495n 1.8v 259.505n 1.8v 269.495n 1.8v 269.505n 1.8v 279.495n 1.8v 279.505n 0.0v 289.495n 0.0v 289.505n 0.0v 299.495n 0.0v 299.505n 1.8v 309.495n 1.8v 309.505n 1.8v 319.495n 1.8v 319.505n 1.8v 329.495n 1.8v 329.505n 1.8v 339.495n 1.8v 339.505n 1.8v 349.495n 1.8v 349.505n 0.0v 359.495n 0.0v 359.505n 0.0v 369.495n 0.0v 369.505n 1.8v 379.495n 1.8v 379.505n 0.0v 389.495n 0.0v 389.505n 0.0v 399.495n 0.0v 399.505n 0.0v 409.495n 0.0v 409.505n 0.0v 419.495n 0.0v 419.505n 0.0v 429.495n 0.0v 429.505n 1.8v 439.495n 1.8v 439.505n 1.8v 449.495n 1.8v 449.505n 1.8v 459.495n 1.8v 459.505n 0.0v 469.495n 0.0v 469.505n 0.0v 479.495n 0.0v 479.505n 0.0v 489.495n 0.0v 489.505n 1.8v 499.495n 1.8v 499.505n 1.8v 509.495n 1.8v 509.505n 0.0v 519.495n 0.0v 519.505n 0.0v 529.495n 0.0v 529.505n 1.8v 539.495n 1.8v 539.505n 1.8v 549.495n 1.8v 549.505n 1.8v 559.495n 1.8v 559.505n 0.0v 569.495n 0.0v 569.505n 1.8v 579.495n 1.8v 579.505n 0.0v 589.495n 0.0v 589.505n 0.0v 599.495n 0.0v 599.505n 0.0v 609.495n 0.0v 609.505n 1.8v 619.495n 1.8v 619.505n 0.0v 629.495n 0.0v 629.505n 0.0v 639.495n 0.0v 639.505n 0.0v 649.495n 0.0v 649.505n 0.0v 659.495n 0.0v 659.505n 1.8v 669.495n 1.8v 669.505n 1.8v 679.495n 1.8v 679.505n 0.0v 689.495n 0.0v 689.505n 0.0v 699.495n 0.0v 699.505n 0.0v 709.495n 0.0v 709.505n 0.0v 719.495n 0.0v 719.505n 0.0v 729.495n 0.0v 729.505n 0.0v 739.495n 0.0v 739.505n 0.0v 749.495n 0.0v 749.505n 0.0v 759.495n 0.0v 759.505n 0.0v 769.495n 0.0v 769.505n 0.0v 779.495n 0.0v 779.505n 0.0v 789.495n 0.0v 789.505n 0.0v 799.495n 0.0v 799.505n 0.0v 809.495n 0.0v 809.505n 0.0v 819.495n 0.0v 819.505n 0.0v 829.495n 0.0v 829.505n 1.8v 839.495n 1.8v 839.505n 0.0v 849.495n 0.0v 849.505n 0.0v 859.495n 0.0v 859.505n 0.0v 869.495n 0.0v 869.505n 0.0v 879.495n 0.0v 879.505n 1.8v 889.495n 1.8v 889.505n 0.0v 899.495n 0.0v 899.505n 0.0v 909.495n 0.0v 909.505n 1.8v 919.495n 1.8v 919.505n 0.0v 929.495n 0.0v 929.505n 0.0v 939.495n 0.0v 939.505n 1.8v 949.495n 1.8v 949.505n 0.0v 959.495n 0.0v 959.505n 1.8v 969.495n 1.8v 969.505n 0.0v 979.495n 0.0v 979.505n 0.0v 989.495n 0.0v 989.505n 0.0v 999.495n 0.0v 999.505n 1.8v 1009.495n 1.8v 1009.505n 1.8v 1019.495n 1.8v 1019.505n 1.8v 1029.495n 1.8v 1029.505n 1.8v 1039.495n 1.8v 1039.505n 1.8v 1049.495n 1.8v 1049.505n 1.8v 1059.495n 1.8v 1059.505n 0.0v 1069.495n 0.0v 1069.505n 1.8v 1079.495n 1.8v 1079.505n 1.8v 1089.495n 1.8v 1089.505n 0.0v 1099.495n 0.0v 1099.505n 0.0v 1109.495n 0.0v 1109.505n 0.0v 1119.495n 0.0v 1119.505n 1.8v 1129.495n 1.8v 1129.505n 0.0v 1139.495n 0.0v 1139.505n 1.8v 1149.495n 1.8v 1149.505n 0.0v 1159.495n 0.0v 1159.505n 1.8v 1169.495n 1.8v 1169.505n 0.0v 1179.495n 0.0v 1179.505n 0.0v 1189.495n 0.0v 1189.505n 1.8v 1199.495n 1.8v 1199.505n 1.8v 1209.495n 1.8v 1209.505n 0.0v 1219.495n 0.0v 1219.505n 0.0v 1229.495n 0.0v 1229.505n 0.0v 1239.495n 0.0v 1239.505n 1.8v 1249.495n 1.8v 1249.505n 0.0v 1259.495n 0.0v 1259.505n 0.0v 1269.495n 0.0v 1269.505n 1.8v 1279.495n 1.8v 1279.505n 0.0v 1289.495n 0.0v 1289.505n 0.0v 1299.495n 0.0v 1299.505n 0.0v 1309.495n 0.0v 1309.505n 0.0v 1319.495n 0.0v 1319.505n 1.8v 1329.495n 1.8v 1329.505n 0.0v 1339.495n 0.0v 1339.505n 0.0v 1349.495n 0.0v 1349.505n 1.8v 1359.495n 1.8v 1359.505n 0.0v 1369.495n 0.0v 1369.505n 0.0v 1379.495n 0.0v 1379.505n 0.0v 1389.495n 0.0v 1389.505n 0.0v 1399.495n 0.0v 1399.505n 0.0v 1409.495n 0.0v 1409.505n 0.0v 1419.495n 0.0v 1419.505n 0.0v 1429.495n 0.0v 1429.505n 1.8v 1439.495n 1.8v 1439.505n 0.0v 1449.495n 0.0v 1449.505n 1.8v 1459.495n 1.8v 1459.505n 1.8v 1469.495n 1.8v 1469.505n 0.0v 1479.495n 0.0v 1479.505n 1.8v 1489.495n 1.8v 1489.505n 1.8v 1499.495n 1.8v 1499.505n 1.8v 1509.495n 1.8v 1509.505n 0.0v 1519.495n 0.0v 1519.505n 0.0v 1529.495n 0.0v 1529.505n 1.8v 1539.495n 1.8v 1539.505n 1.8v 1549.495n 1.8v 1549.505n 0.0v 1559.495n 0.0v 1559.505n 0.0v 1569.495n 0.0v 1569.505n 1.8v 1579.495n 1.8v 1579.505n 1.8v 1589.495n 1.8v 1589.505n 0.0v 1599.495n 0.0v 1599.505n 0.0v 1609.495n 0.0v 1609.505n 0.0v 1619.495n 0.0v 1619.505n 1.8v 1629.495n 1.8v 1629.505n 0.0v 1639.495n 0.0v 1639.505n 0.0v 1649.495n 0.0v 1649.505n 1.8v 1659.495n 1.8v 1659.505n 0.0v 1669.495n 0.0v 1669.505n 1.8v 1679.495n 1.8v 1679.505n 1.8v 1689.495n 1.8v 1689.505n 1.8v 1699.495n 1.8v 1699.505n 1.8v 1709.495n 1.8v 1709.505n 1.8v 1719.495n 1.8v 1719.505n 0.0v 1729.495n 0.0v 1729.505n 0.0v 1739.495n 0.0v 1739.505n 0.0v 1749.495n 0.0v 1749.505n 0.0v 1759.495n 0.0v 1759.505n 0.0v 1769.495n 0.0v 1769.505n 1.8v 1779.495n 1.8v 1779.505n 1.8v 1789.495n 1.8v 1789.505n 0.0v 1799.495n 0.0v 1799.505n 1.8v 1809.495n 1.8v 1809.505n 0.0v 1819.495n 0.0v 1819.505n 0.0v 1829.495n 0.0v 1829.505n 1.8v 1839.495n 1.8v 1839.505n 0.0v 1849.495n 0.0v 1849.505n 0.0v 1859.495n 0.0v 1859.505n 0.0v 1869.495n 0.0v 1869.505n 0.0v 1879.495n 0.0v 1879.505n 1.8v 1889.495n 1.8v 1889.505n 0.0v 1899.495n 0.0v 1899.505n 1.8v 1909.495n 1.8v 1909.505n 1.8v 1919.495n 1.8v 1919.505n 1.8v 1929.495n 1.8v 1929.505n 1.8v 1939.495n 1.8v 1939.505n 0.0v 1949.495n 0.0v 1949.505n 0.0v 1959.495n 0.0v 1959.505n 0.0v 1969.495n 0.0v 1969.505n 0.0v 1979.495n 0.0v 1979.505n 0.0v 1989.495n 0.0v 1989.505n 1.8v 1999.495n 1.8v 1999.505n 1.8v 2009.495n 1.8v 2009.505n 1.8v 2019.495n 1.8v 2019.505n 1.8v 2029.495n 1.8v 2029.505n 1.8v 2039.495n 1.8v 2039.505n 1.8v 2049.495n 1.8v 2049.505n 1.8v )
* (time, data): [(0, 0), (10, 1), (20, 0), (30, 0), (40, 0), (50, 1), (60, 1), (70, 0), (80, 1), (90, 1), (100, 1), (110, 1), (120, 1), (130, 0), (140, 1), (150, 1), (160, 1), (170, 1), (180, 1), (190, 1), (200, 0), (210, 1), (220, 1), (230, 0), (240, 0), (250, 1), (260, 1), (270, 1), (280, 0), (290, 0), (300, 1), (310, 1), (320, 1), (330, 1), (340, 1), (350, 0), (360, 0), (370, 1), (380, 0), (390, 0), (400, 0), (410, 0), (420, 0), (430, 1), (440, 1), (450, 1), (460, 0), (470, 0), (480, 0), (490, 1), (500, 1), (510, 0), (520, 0), (530, 1), (540, 1), (550, 1), (560, 0), (570, 1), (580, 0), (590, 0), (600, 0), (610, 1), (620, 0), (630, 0), (640, 0), (650, 0), (660, 1), (670, 1), (680, 0), (690, 0), (700, 0), (710, 0), (720, 0), (730, 0), (740, 0), (750, 0), (760, 0), (770, 0), (780, 0), (790, 0), (800, 0), (810, 0), (820, 0), (830, 1), (840, 0), (850, 0), (860, 0), (870, 0), (880, 1), (890, 0), (900, 0), (910, 1), (920, 0), (930, 0), (940, 1), (950, 0), (960, 1), (970, 0), (980, 0), (990, 0), (1000, 1), (1010, 1), (1020, 1), (1030, 1), (1040, 1), (1050, 1), (1060, 0), (1070, 1), (1080, 1), (1090, 0), (1100, 0), (1110, 0), (1120, 1), (1130, 0), (1140, 1), (1150, 0), (1160, 1), (1170, 0), (1180, 0), (1190, 1), (1200, 1), (1210, 0), (1220, 0), (1230, 0), (1240, 1), (1250, 0), (1260, 0), (1270, 1), (1280, 0), (1290, 0), (1300, 0), (1310, 0), (1320, 1), (1330, 0), (1340, 0), (1350, 1), (1360, 0), (1370, 0), (1380, 0), (1390, 0), (1400, 0), (1410, 0), (1420, 0), (1430, 1), (1440, 0), (1450, 1), (1460, 1), (1470, 0), (1480, 1), (1490, 1), (1500, 1), (1510, 0), (1520, 0), (1530, 1), (1540, 1), (1550, 0), (1560, 0), (1570, 1), (1580, 1), (1590, 0), (1600, 0), (1610, 0), (1620, 1), (1630, 0), (1640, 0), (1650, 1), (1660, 0), (1670, 1), (1680, 1), (1690, 1), (1700, 1), (1710, 1), (1720, 0), (1730, 0), (1740, 0), (1750, 0), (1760, 0), (1770, 1), (1780, 1), (1790, 0), (1800, 1), (1810, 0), (1820, 0), (1830, 1), (1840, 0), (1850, 0), (1860, 0), (1870, 0), (1880, 1), (1890, 0), (1900, 1), (1910, 1), (1920, 1), (1930, 1), (1940, 0), (1950, 0), (1960, 0), (1970, 0), (1980, 0), (1990, 1), (2000, 1), (2010, 1), (2020, 1), (2030, 1), (2040, 1), (2050, 1)]
Va0_9  a0_9  0 PWL (0n 0.0v 9.495n 0.0v 9.505n 1.8v 19.495n 1.8v 19.505n 0.0v 29.495n 0.0v 29.505n 0.0v 39.495n 0.0v 39.505n 0.0v 49.495n 0.0v 49.505n 1.8v 59.495n 1.8v 59.505n 1.8v 69.495n 1.8v 69.505n 0.0v 79.495n 0.0v 79.505n 1.8v 89.495n 1.8v 89.505n 1.8v 99.495n 1.8v 99.505n 1.8v 109.495n 1.8v 109.505n 1.8v 119.495n 1.8v 119.505n 1.8v 129.495n 1.8v 129.505n 0.0v 139.495n 0.0v 139.505n 1.8v 149.495n 1.8v 149.505n 1.8v 159.495n 1.8v 159.505n 1.8v 169.495n 1.8v 169.505n 1.8v 179.495n 1.8v 179.505n 1.8v 189.495n 1.8v 189.505n 1.8v 199.495n 1.8v 199.505n 0.0v 209.495n 0.0v 209.505n 1.8v 219.495n 1.8v 219.505n 1.8v 229.495n 1.8v 229.505n 0.0v 239.495n 0.0v 239.505n 0.0v 249.495n 0.0v 249.505n 1.8v 259.495n 1.8v 259.505n 1.8v 269.495n 1.8v 269.505n 1.8v 279.495n 1.8v 279.505n 0.0v 289.495n 0.0v 289.505n 0.0v 299.495n 0.0v 299.505n 1.8v 309.495n 1.8v 309.505n 1.8v 319.495n 1.8v 319.505n 1.8v 329.495n 1.8v 329.505n 1.8v 339.495n 1.8v 339.505n 1.8v 349.495n 1.8v 349.505n 0.0v 359.495n 0.0v 359.505n 0.0v 369.495n 0.0v 369.505n 1.8v 379.495n 1.8v 379.505n 0.0v 389.495n 0.0v 389.505n 0.0v 399.495n 0.0v 399.505n 0.0v 409.495n 0.0v 409.505n 0.0v 419.495n 0.0v 419.505n 0.0v 429.495n 0.0v 429.505n 1.8v 439.495n 1.8v 439.505n 1.8v 449.495n 1.8v 449.505n 1.8v 459.495n 1.8v 459.505n 0.0v 469.495n 0.0v 469.505n 0.0v 479.495n 0.0v 479.505n 0.0v 489.495n 0.0v 489.505n 1.8v 499.495n 1.8v 499.505n 1.8v 509.495n 1.8v 509.505n 0.0v 519.495n 0.0v 519.505n 0.0v 529.495n 0.0v 529.505n 1.8v 539.495n 1.8v 539.505n 1.8v 549.495n 1.8v 549.505n 1.8v 559.495n 1.8v 559.505n 0.0v 569.495n 0.0v 569.505n 1.8v 579.495n 1.8v 579.505n 0.0v 589.495n 0.0v 589.505n 0.0v 599.495n 0.0v 599.505n 0.0v 609.495n 0.0v 609.505n 1.8v 619.495n 1.8v 619.505n 0.0v 629.495n 0.0v 629.505n 0.0v 639.495n 0.0v 639.505n 0.0v 649.495n 0.0v 649.505n 0.0v 659.495n 0.0v 659.505n 1.8v 669.495n 1.8v 669.505n 1.8v 679.495n 1.8v 679.505n 0.0v 689.495n 0.0v 689.505n 0.0v 699.495n 0.0v 699.505n 0.0v 709.495n 0.0v 709.505n 0.0v 719.495n 0.0v 719.505n 0.0v 729.495n 0.0v 729.505n 0.0v 739.495n 0.0v 739.505n 0.0v 749.495n 0.0v 749.505n 0.0v 759.495n 0.0v 759.505n 0.0v 769.495n 0.0v 769.505n 0.0v 779.495n 0.0v 779.505n 0.0v 789.495n 0.0v 789.505n 0.0v 799.495n 0.0v 799.505n 0.0v 809.495n 0.0v 809.505n 0.0v 819.495n 0.0v 819.505n 0.0v 829.495n 0.0v 829.505n 1.8v 839.495n 1.8v 839.505n 0.0v 849.495n 0.0v 849.505n 0.0v 859.495n 0.0v 859.505n 0.0v 869.495n 0.0v 869.505n 0.0v 879.495n 0.0v 879.505n 1.8v 889.495n 1.8v 889.505n 0.0v 899.495n 0.0v 899.505n 0.0v 909.495n 0.0v 909.505n 1.8v 919.495n 1.8v 919.505n 0.0v 929.495n 0.0v 929.505n 0.0v 939.495n 0.0v 939.505n 1.8v 949.495n 1.8v 949.505n 0.0v 959.495n 0.0v 959.505n 1.8v 969.495n 1.8v 969.505n 0.0v 979.495n 0.0v 979.505n 0.0v 989.495n 0.0v 989.505n 0.0v 999.495n 0.0v 999.505n 1.8v 1009.495n 1.8v 1009.505n 1.8v 1019.495n 1.8v 1019.505n 1.8v 1029.495n 1.8v 1029.505n 1.8v 1039.495n 1.8v 1039.505n 1.8v 1049.495n 1.8v 1049.505n 1.8v 1059.495n 1.8v 1059.505n 0.0v 1069.495n 0.0v 1069.505n 1.8v 1079.495n 1.8v 1079.505n 1.8v 1089.495n 1.8v 1089.505n 0.0v 1099.495n 0.0v 1099.505n 0.0v 1109.495n 0.0v 1109.505n 0.0v 1119.495n 0.0v 1119.505n 1.8v 1129.495n 1.8v 1129.505n 0.0v 1139.495n 0.0v 1139.505n 1.8v 1149.495n 1.8v 1149.505n 0.0v 1159.495n 0.0v 1159.505n 1.8v 1169.495n 1.8v 1169.505n 0.0v 1179.495n 0.0v 1179.505n 0.0v 1189.495n 0.0v 1189.505n 1.8v 1199.495n 1.8v 1199.505n 1.8v 1209.495n 1.8v 1209.505n 0.0v 1219.495n 0.0v 1219.505n 0.0v 1229.495n 0.0v 1229.505n 0.0v 1239.495n 0.0v 1239.505n 1.8v 1249.495n 1.8v 1249.505n 0.0v 1259.495n 0.0v 1259.505n 0.0v 1269.495n 0.0v 1269.505n 1.8v 1279.495n 1.8v 1279.505n 0.0v 1289.495n 0.0v 1289.505n 0.0v 1299.495n 0.0v 1299.505n 0.0v 1309.495n 0.0v 1309.505n 0.0v 1319.495n 0.0v 1319.505n 1.8v 1329.495n 1.8v 1329.505n 0.0v 1339.495n 0.0v 1339.505n 0.0v 1349.495n 0.0v 1349.505n 1.8v 1359.495n 1.8v 1359.505n 0.0v 1369.495n 0.0v 1369.505n 0.0v 1379.495n 0.0v 1379.505n 0.0v 1389.495n 0.0v 1389.505n 0.0v 1399.495n 0.0v 1399.505n 0.0v 1409.495n 0.0v 1409.505n 0.0v 1419.495n 0.0v 1419.505n 0.0v 1429.495n 0.0v 1429.505n 1.8v 1439.495n 1.8v 1439.505n 0.0v 1449.495n 0.0v 1449.505n 1.8v 1459.495n 1.8v 1459.505n 1.8v 1469.495n 1.8v 1469.505n 0.0v 1479.495n 0.0v 1479.505n 1.8v 1489.495n 1.8v 1489.505n 1.8v 1499.495n 1.8v 1499.505n 1.8v 1509.495n 1.8v 1509.505n 0.0v 1519.495n 0.0v 1519.505n 0.0v 1529.495n 0.0v 1529.505n 1.8v 1539.495n 1.8v 1539.505n 1.8v 1549.495n 1.8v 1549.505n 0.0v 1559.495n 0.0v 1559.505n 0.0v 1569.495n 0.0v 1569.505n 1.8v 1579.495n 1.8v 1579.505n 1.8v 1589.495n 1.8v 1589.505n 0.0v 1599.495n 0.0v 1599.505n 0.0v 1609.495n 0.0v 1609.505n 0.0v 1619.495n 0.0v 1619.505n 1.8v 1629.495n 1.8v 1629.505n 0.0v 1639.495n 0.0v 1639.505n 0.0v 1649.495n 0.0v 1649.505n 1.8v 1659.495n 1.8v 1659.505n 0.0v 1669.495n 0.0v 1669.505n 1.8v 1679.495n 1.8v 1679.505n 1.8v 1689.495n 1.8v 1689.505n 1.8v 1699.495n 1.8v 1699.505n 1.8v 1709.495n 1.8v 1709.505n 1.8v 1719.495n 1.8v 1719.505n 0.0v 1729.495n 0.0v 1729.505n 0.0v 1739.495n 0.0v 1739.505n 0.0v 1749.495n 0.0v 1749.505n 0.0v 1759.495n 0.0v 1759.505n 0.0v 1769.495n 0.0v 1769.505n 1.8v 1779.495n 1.8v 1779.505n 1.8v 1789.495n 1.8v 1789.505n 0.0v 1799.495n 0.0v 1799.505n 1.8v 1809.495n 1.8v 1809.505n 0.0v 1819.495n 0.0v 1819.505n 0.0v 1829.495n 0.0v 1829.505n 1.8v 1839.495n 1.8v 1839.505n 0.0v 1849.495n 0.0v 1849.505n 0.0v 1859.495n 0.0v 1859.505n 0.0v 1869.495n 0.0v 1869.505n 0.0v 1879.495n 0.0v 1879.505n 1.8v 1889.495n 1.8v 1889.505n 0.0v 1899.495n 0.0v 1899.505n 1.8v 1909.495n 1.8v 1909.505n 1.8v 1919.495n 1.8v 1919.505n 1.8v 1929.495n 1.8v 1929.505n 1.8v 1939.495n 1.8v 1939.505n 0.0v 1949.495n 0.0v 1949.505n 0.0v 1959.495n 0.0v 1959.505n 0.0v 1969.495n 0.0v 1969.505n 0.0v 1979.495n 0.0v 1979.505n 0.0v 1989.495n 0.0v 1989.505n 1.8v 1999.495n 1.8v 1999.505n 1.8v 2009.495n 1.8v 2009.505n 1.8v 2019.495n 1.8v 2019.505n 1.8v 2029.495n 1.8v 2029.505n 1.8v 2039.495n 1.8v 2039.505n 1.8v 2049.495n 1.8v 2049.505n 1.8v )
* (time, data): [(0, 0), (10, 0), (20, 0), (30, 0), (40, 0), (50, 0), (60, 0), (70, 0), (80, 0), (90, 0), (100, 1), (110, 1), (120, 1), (130, 0), (140, 1), (150, 1), (160, 1), (170, 1), (180, 1), (190, 0), (200, 0), (210, 0), (220, 1), (230, 0), (240, 1), (250, 1), (260, 0), (270, 0), (280, 0), (290, 1), (300, 1), (310, 1), (320, 1), (330, 1), (340, 1), (350, 1), (360, 1), (370, 1), (380, 1), (390, 1), (400, 1), (410, 1), (420, 1), (430, 1), (440, 1), (450, 1), (460, 1), (470, 0), (480, 0), (490, 0), (500, 0), (510, 0), (520, 0), (530, 1), (540, 1), (550, 1), (560, 1), (570, 1), (580, 1), (590, 1), (600, 1), (610, 1), (620, 1), (630, 1), (640, 1), (650, 1), (660, 1), (670, 1), (680, 1), (690, 0), (700, 0), (710, 0), (720, 0), (730, 0), (740, 0), (750, 0), (760, 0), (770, 1), (780, 1), (790, 0), (800, 1), (810, 1), (820, 1), (830, 0), (840, 1), (850, 1), (860, 1), (870, 1), (880, 1), (890, 1), (900, 1), (910, 1), (920, 1), (930, 1), (940, 1), (950, 1), (960, 1), (970, 1), (980, 1), (990, 1), (1000, 1), (1010, 1), (1020, 1), (1030, 1), (1040, 0), (1050, 0), (1060, 0), (1070, 0), (1080, 0), (1090, 0), (1100, 0), (1110, 1), (1120, 1), (1130, 1), (1140, 1), (1150, 1), (1160, 1), (1170, 1), (1180, 1), (1190, 1), (1200, 1), (1210, 0), (1220, 0), (1230, 1), (1240, 1), (1250, 1), (1260, 1), (1270, 1), (1280, 1), (1290, 1), (1300, 1), (1310, 0), (1320, 1), (1330, 1), (1340, 0), (1350, 0), (1360, 0), (1370, 0), (1380, 0), (1390, 0), (1400, 0), (1410, 0), (1420, 0), (1430, 1), (1440, 1), (1450, 1), (1460, 1), (1470, 1), (1480, 1), (1490, 0), (1500, 1), (1510, 1), (1520, 1), (1530, 1), (1540, 1), (1550, 1), (1560, 0), (1570, 0), (1580, 0), (1590, 0), (1600, 0), (1610, 0), (1620, 0), (1630, 0), (1640, 0), (1650, 0), (1660, 0), (1670, 0), (1680, 1), (1690, 1), (1700, 1), (1710, 1), (1720, 1), (1730, 1), (1740, 1), (1750, 1), (1760, 1), (1770, 1), (1780, 1), (1790, 0), (1800, 1), (1810, 1), (1820, 1), (1830, 1), (1840, 0), (1850, 1), (1860, 1), (1870, 0), (1880, 0), (1890, 0), (1900, 1), (1910, 1), (1920, 1), (1930, 1), (1940, 1), (1950, 1), (1960, 1), (1970, 1), (1980, 1), (1990, 1), (2000, 1), (2010, 1), (2020, 0), (2030, 0), (2040, 0), (2050, 0)]
Va1_0  a1_0  0 PWL (0n 0.0v 9.495n 0.0v 9.505n 0.0v 19.495n 0.0v 19.505n 0.0v 29.495n 0.0v 29.505n 0.0v 39.495n 0.0v 39.505n 0.0v 49.495n 0.0v 49.505n 0.0v 59.495n 0.0v 59.505n 0.0v 69.495n 0.0v 69.505n 0.0v 79.495n 0.0v 79.505n 0.0v 89.495n 0.0v 89.505n 0.0v 99.495n 0.0v 99.505n 1.8v 109.495n 1.8v 109.505n 1.8v 119.495n 1.8v 119.505n 1.8v 129.495n 1.8v 129.505n 0.0v 139.495n 0.0v 139.505n 1.8v 149.495n 1.8v 149.505n 1.8v 159.495n 1.8v 159.505n 1.8v 169.495n 1.8v 169.505n 1.8v 179.495n 1.8v 179.505n 1.8v 189.495n 1.8v 189.505n 0.0v 199.495n 0.0v 199.505n 0.0v 209.495n 0.0v 209.505n 0.0v 219.495n 0.0v 219.505n 1.8v 229.495n 1.8v 229.505n 0.0v 239.495n 0.0v 239.505n 1.8v 249.495n 1.8v 249.505n 1.8v 259.495n 1.8v 259.505n 0.0v 269.495n 0.0v 269.505n 0.0v 279.495n 0.0v 279.505n 0.0v 289.495n 0.0v 289.505n 1.8v 299.495n 1.8v 299.505n 1.8v 309.495n 1.8v 309.505n 1.8v 319.495n 1.8v 319.505n 1.8v 329.495n 1.8v 329.505n 1.8v 339.495n 1.8v 339.505n 1.8v 349.495n 1.8v 349.505n 1.8v 359.495n 1.8v 359.505n 1.8v 369.495n 1.8v 369.505n 1.8v 379.495n 1.8v 379.505n 1.8v 389.495n 1.8v 389.505n 1.8v 399.495n 1.8v 399.505n 1.8v 409.495n 1.8v 409.505n 1.8v 419.495n 1.8v 419.505n 1.8v 429.495n 1.8v 429.505n 1.8v 439.495n 1.8v 439.505n 1.8v 449.495n 1.8v 449.505n 1.8v 459.495n 1.8v 459.505n 1.8v 469.495n 1.8v 469.505n 0.0v 479.495n 0.0v 479.505n 0.0v 489.495n 0.0v 489.505n 0.0v 499.495n 0.0v 499.505n 0.0v 509.495n 0.0v 509.505n 0.0v 519.495n 0.0v 519.505n 0.0v 529.495n 0.0v 529.505n 1.8v 539.495n 1.8v 539.505n 1.8v 549.495n 1.8v 549.505n 1.8v 559.495n 1.8v 559.505n 1.8v 569.495n 1.8v 569.505n 1.8v 579.495n 1.8v 579.505n 1.8v 589.495n 1.8v 589.505n 1.8v 599.495n 1.8v 599.505n 1.8v 609.495n 1.8v 609.505n 1.8v 619.495n 1.8v 619.505n 1.8v 629.495n 1.8v 629.505n 1.8v 639.495n 1.8v 639.505n 1.8v 649.495n 1.8v 649.505n 1.8v 659.495n 1.8v 659.505n 1.8v 669.495n 1.8v 669.505n 1.8v 679.495n 1.8v 679.505n 1.8v 689.495n 1.8v 689.505n 0.0v 699.495n 0.0v 699.505n 0.0v 709.495n 0.0v 709.505n 0.0v 719.495n 0.0v 719.505n 0.0v 729.495n 0.0v 729.505n 0.0v 739.495n 0.0v 739.505n 0.0v 749.495n 0.0v 749.505n 0.0v 759.495n 0.0v 759.505n 0.0v 769.495n 0.0v 769.505n 1.8v 779.495n 1.8v 779.505n 1.8v 789.495n 1.8v 789.505n 0.0v 799.495n 0.0v 799.505n 1.8v 809.495n 1.8v 809.505n 1.8v 819.495n 1.8v 819.505n 1.8v 829.495n 1.8v 829.505n 0.0v 839.495n 0.0v 839.505n 1.8v 849.495n 1.8v 849.505n 1.8v 859.495n 1.8v 859.505n 1.8v 869.495n 1.8v 869.505n 1.8v 879.495n 1.8v 879.505n 1.8v 889.495n 1.8v 889.505n 1.8v 899.495n 1.8v 899.505n 1.8v 909.495n 1.8v 909.505n 1.8v 919.495n 1.8v 919.505n 1.8v 929.495n 1.8v 929.505n 1.8v 939.495n 1.8v 939.505n 1.8v 949.495n 1.8v 949.505n 1.8v 959.495n 1.8v 959.505n 1.8v 969.495n 1.8v 969.505n 1.8v 979.495n 1.8v 979.505n 1.8v 989.495n 1.8v 989.505n 1.8v 999.495n 1.8v 999.505n 1.8v 1009.495n 1.8v 1009.505n 1.8v 1019.495n 1.8v 1019.505n 1.8v 1029.495n 1.8v 1029.505n 1.8v 1039.495n 1.8v 1039.505n 0.0v 1049.495n 0.0v 1049.505n 0.0v 1059.495n 0.0v 1059.505n 0.0v 1069.495n 0.0v 1069.505n 0.0v 1079.495n 0.0v 1079.505n 0.0v 1089.495n 0.0v 1089.505n 0.0v 1099.495n 0.0v 1099.505n 0.0v 1109.495n 0.0v 1109.505n 1.8v 1119.495n 1.8v 1119.505n 1.8v 1129.495n 1.8v 1129.505n 1.8v 1139.495n 1.8v 1139.505n 1.8v 1149.495n 1.8v 1149.505n 1.8v 1159.495n 1.8v 1159.505n 1.8v 1169.495n 1.8v 1169.505n 1.8v 1179.495n 1.8v 1179.505n 1.8v 1189.495n 1.8v 1189.505n 1.8v 1199.495n 1.8v 1199.505n 1.8v 1209.495n 1.8v 1209.505n 0.0v 1219.495n 0.0v 1219.505n 0.0v 1229.495n 0.0v 1229.505n 1.8v 1239.495n 1.8v 1239.505n 1.8v 1249.495n 1.8v 1249.505n 1.8v 1259.495n 1.8v 1259.505n 1.8v 1269.495n 1.8v 1269.505n 1.8v 1279.495n 1.8v 1279.505n 1.8v 1289.495n 1.8v 1289.505n 1.8v 1299.495n 1.8v 1299.505n 1.8v 1309.495n 1.8v 1309.505n 0.0v 1319.495n 0.0v 1319.505n 1.8v 1329.495n 1.8v 1329.505n 1.8v 1339.495n 1.8v 1339.505n 0.0v 1349.495n 0.0v 1349.505n 0.0v 1359.495n 0.0v 1359.505n 0.0v 1369.495n 0.0v 1369.505n 0.0v 1379.495n 0.0v 1379.505n 0.0v 1389.495n 0.0v 1389.505n 0.0v 1399.495n 0.0v 1399.505n 0.0v 1409.495n 0.0v 1409.505n 0.0v 1419.495n 0.0v 1419.505n 0.0v 1429.495n 0.0v 1429.505n 1.8v 1439.495n 1.8v 1439.505n 1.8v 1449.495n 1.8v 1449.505n 1.8v 1459.495n 1.8v 1459.505n 1.8v 1469.495n 1.8v 1469.505n 1.8v 1479.495n 1.8v 1479.505n 1.8v 1489.495n 1.8v 1489.505n 0.0v 1499.495n 0.0v 1499.505n 1.8v 1509.495n 1.8v 1509.505n 1.8v 1519.495n 1.8v 1519.505n 1.8v 1529.495n 1.8v 1529.505n 1.8v 1539.495n 1.8v 1539.505n 1.8v 1549.495n 1.8v 1549.505n 1.8v 1559.495n 1.8v 1559.505n 0.0v 1569.495n 0.0v 1569.505n 0.0v 1579.495n 0.0v 1579.505n 0.0v 1589.495n 0.0v 1589.505n 0.0v 1599.495n 0.0v 1599.505n 0.0v 1609.495n 0.0v 1609.505n 0.0v 1619.495n 0.0v 1619.505n 0.0v 1629.495n 0.0v 1629.505n 0.0v 1639.495n 0.0v 1639.505n 0.0v 1649.495n 0.0v 1649.505n 0.0v 1659.495n 0.0v 1659.505n 0.0v 1669.495n 0.0v 1669.505n 0.0v 1679.495n 0.0v 1679.505n 1.8v 1689.495n 1.8v 1689.505n 1.8v 1699.495n 1.8v 1699.505n 1.8v 1709.495n 1.8v 1709.505n 1.8v 1719.495n 1.8v 1719.505n 1.8v 1729.495n 1.8v 1729.505n 1.8v 1739.495n 1.8v 1739.505n 1.8v 1749.495n 1.8v 1749.505n 1.8v 1759.495n 1.8v 1759.505n 1.8v 1769.495n 1.8v 1769.505n 1.8v 1779.495n 1.8v 1779.505n 1.8v 1789.495n 1.8v 1789.505n 0.0v 1799.495n 0.0v 1799.505n 1.8v 1809.495n 1.8v 1809.505n 1.8v 1819.495n 1.8v 1819.505n 1.8v 1829.495n 1.8v 1829.505n 1.8v 1839.495n 1.8v 1839.505n 0.0v 1849.495n 0.0v 1849.505n 1.8v 1859.495n 1.8v 1859.505n 1.8v 1869.495n 1.8v 1869.505n 0.0v 1879.495n 0.0v 1879.505n 0.0v 1889.495n 0.0v 1889.505n 0.0v 1899.495n 0.0v 1899.505n 1.8v 1909.495n 1.8v 1909.505n 1.8v 1919.495n 1.8v 1919.505n 1.8v 1929.495n 1.8v 1929.505n 1.8v 1939.495n 1.8v 1939.505n 1.8v 1949.495n 1.8v 1949.505n 1.8v 1959.495n 1.8v 1959.505n 1.8v 1969.495n 1.8v 1969.505n 1.8v 1979.495n 1.8v 1979.505n 1.8v 1989.495n 1.8v 1989.505n 1.8v 1999.495n 1.8v 1999.505n 1.8v 2009.495n 1.8v 2009.505n 1.8v 2019.495n 1.8v 2019.505n 0.0v 2029.495n 0.0v 2029.505n 0.0v 2039.495n 0.0v 2039.505n 0.0v 2049.495n 0.0v 2049.505n 0.0v )
* (time, data): [(0, 0), (10, 0), (20, 0), (30, 0), (40, 1), (50, 1), (60, 1), (70, 1), (80, 1), (90, 1), (100, 1), (110, 1), (120, 1), (130, 1), (140, 1), (150, 1), (160, 1), (170, 1), (180, 1), (190, 1), (200, 1), (210, 1), (220, 1), (230, 1), (240, 0), (250, 0), (260, 1), (270, 1), (280, 1), (290, 0), (300, 0), (310, 0), (320, 0), (330, 0), (340, 1), (350, 1), (360, 1), (370, 1), (380, 0), (390, 1), (400, 1), (410, 1), (420, 1), (430, 1), (440, 1), (450, 1), (460, 1), (470, 1), (480, 1), (490, 1), (500, 1), (510, 1), (520, 1), (530, 1), (540, 1), (550, 1), (560, 1), (570, 0), (580, 0), (590, 0), (600, 1), (610, 1), (620, 1), (630, 1), (640, 1), (650, 1), (660, 1), (670, 1), (680, 1), (690, 1), (700, 1), (710, 1), (720, 1), (730, 1), (740, 1), (750, 1), (760, 1), (770, 0), (780, 0), (790, 0), (800, 0), (810, 1), (820, 1), (830, 0), (840, 1), (850, 0), (860, 1), (870, 1), (880, 1), (890, 1), (900, 1), (910, 1), (920, 1), (930, 1), (940, 0), (950, 0), (960, 0), (970, 0), (980, 0), (990, 1), (1000, 1), (1010, 1), (1020, 1), (1030, 1), (1040, 1), (1050, 1), (1060, 1), (1070, 1), (1080, 0), (1090, 0), (1100, 0), (1110, 0), (1120, 0), (1130, 0), (1140, 0), (1150, 0), (1160, 0), (1170, 0), (1180, 1), (1190, 1), (1200, 1), (1210, 1), (1220, 1), (1230, 1), (1240, 1), (1250, 1), (1260, 1), (1270, 1), (1280, 1), (1290, 0), (1300, 0), (1310, 1), (1320, 1), (1330, 1), (1340, 1), (1350, 0), (1360, 0), (1370, 0), (1380, 1), (1390, 1), (1400, 1), (1410, 1), (1420, 0), (1430, 0), (1440, 0), (1450, 1), (1460, 1), (1470, 1), (1480, 1), (1490, 0), (1500, 1), (1510, 1), (1520, 1), (1530, 1), (1540, 1), (1550, 1), (1560, 1), (1570, 1), (1580, 1), (1590, 1), (1600, 1), (1610, 1), (1620, 1), (1630, 1), (1640, 0), (1650, 1), (1660, 1), (1670, 1), (1680, 0), (1690, 1), (1700, 0), (1710, 1), (1720, 1), (1730, 0), (1740, 1), (1750, 1), (1760, 1), (1770, 1), (1780, 1), (1790, 1), (1800, 1), (1810, 0), (1820, 1), (1830, 1), (1840, 1), (1850, 0), (1860, 0), (1870, 1), (1880, 0), (1890, 0), (1900, 0), (1910, 0), (1920, 0), (1930, 1), (1940, 1), (1950, 1), (1960, 0), (1970, 0), (1980, 0), (1990, 0), (2000, 0), (2010, 1), (2020, 0), (2030, 0), (2040, 0), (2050, 0)]
Va1_1  a1_1  0 PWL (0n 0.0v 9.495n 0.0v 9.505n 0.0v 19.495n 0.0v 19.505n 0.0v 29.495n 0.0v 29.505n 0.0v 39.495n 0.0v 39.505n 1.8v 49.495n 1.8v 49.505n 1.8v 59.495n 1.8v 59.505n 1.8v 69.495n 1.8v 69.505n 1.8v 79.495n 1.8v 79.505n 1.8v 89.495n 1.8v 89.505n 1.8v 99.495n 1.8v 99.505n 1.8v 109.495n 1.8v 109.505n 1.8v 119.495n 1.8v 119.505n 1.8v 129.495n 1.8v 129.505n 1.8v 139.495n 1.8v 139.505n 1.8v 149.495n 1.8v 149.505n 1.8v 159.495n 1.8v 159.505n 1.8v 169.495n 1.8v 169.505n 1.8v 179.495n 1.8v 179.505n 1.8v 189.495n 1.8v 189.505n 1.8v 199.495n 1.8v 199.505n 1.8v 209.495n 1.8v 209.505n 1.8v 219.495n 1.8v 219.505n 1.8v 229.495n 1.8v 229.505n 1.8v 239.495n 1.8v 239.505n 0.0v 249.495n 0.0v 249.505n 0.0v 259.495n 0.0v 259.505n 1.8v 269.495n 1.8v 269.505n 1.8v 279.495n 1.8v 279.505n 1.8v 289.495n 1.8v 289.505n 0.0v 299.495n 0.0v 299.505n 0.0v 309.495n 0.0v 309.505n 0.0v 319.495n 0.0v 319.505n 0.0v 329.495n 0.0v 329.505n 0.0v 339.495n 0.0v 339.505n 1.8v 349.495n 1.8v 349.505n 1.8v 359.495n 1.8v 359.505n 1.8v 369.495n 1.8v 369.505n 1.8v 379.495n 1.8v 379.505n 0.0v 389.495n 0.0v 389.505n 1.8v 399.495n 1.8v 399.505n 1.8v 409.495n 1.8v 409.505n 1.8v 419.495n 1.8v 419.505n 1.8v 429.495n 1.8v 429.505n 1.8v 439.495n 1.8v 439.505n 1.8v 449.495n 1.8v 449.505n 1.8v 459.495n 1.8v 459.505n 1.8v 469.495n 1.8v 469.505n 1.8v 479.495n 1.8v 479.505n 1.8v 489.495n 1.8v 489.505n 1.8v 499.495n 1.8v 499.505n 1.8v 509.495n 1.8v 509.505n 1.8v 519.495n 1.8v 519.505n 1.8v 529.495n 1.8v 529.505n 1.8v 539.495n 1.8v 539.505n 1.8v 549.495n 1.8v 549.505n 1.8v 559.495n 1.8v 559.505n 1.8v 569.495n 1.8v 569.505n 0.0v 579.495n 0.0v 579.505n 0.0v 589.495n 0.0v 589.505n 0.0v 599.495n 0.0v 599.505n 1.8v 609.495n 1.8v 609.505n 1.8v 619.495n 1.8v 619.505n 1.8v 629.495n 1.8v 629.505n 1.8v 639.495n 1.8v 639.505n 1.8v 649.495n 1.8v 649.505n 1.8v 659.495n 1.8v 659.505n 1.8v 669.495n 1.8v 669.505n 1.8v 679.495n 1.8v 679.505n 1.8v 689.495n 1.8v 689.505n 1.8v 699.495n 1.8v 699.505n 1.8v 709.495n 1.8v 709.505n 1.8v 719.495n 1.8v 719.505n 1.8v 729.495n 1.8v 729.505n 1.8v 739.495n 1.8v 739.505n 1.8v 749.495n 1.8v 749.505n 1.8v 759.495n 1.8v 759.505n 1.8v 769.495n 1.8v 769.505n 0.0v 779.495n 0.0v 779.505n 0.0v 789.495n 0.0v 789.505n 0.0v 799.495n 0.0v 799.505n 0.0v 809.495n 0.0v 809.505n 1.8v 819.495n 1.8v 819.505n 1.8v 829.495n 1.8v 829.505n 0.0v 839.495n 0.0v 839.505n 1.8v 849.495n 1.8v 849.505n 0.0v 859.495n 0.0v 859.505n 1.8v 869.495n 1.8v 869.505n 1.8v 879.495n 1.8v 879.505n 1.8v 889.495n 1.8v 889.505n 1.8v 899.495n 1.8v 899.505n 1.8v 909.495n 1.8v 909.505n 1.8v 919.495n 1.8v 919.505n 1.8v 929.495n 1.8v 929.505n 1.8v 939.495n 1.8v 939.505n 0.0v 949.495n 0.0v 949.505n 0.0v 959.495n 0.0v 959.505n 0.0v 969.495n 0.0v 969.505n 0.0v 979.495n 0.0v 979.505n 0.0v 989.495n 0.0v 989.505n 1.8v 999.495n 1.8v 999.505n 1.8v 1009.495n 1.8v 1009.505n 1.8v 1019.495n 1.8v 1019.505n 1.8v 1029.495n 1.8v 1029.505n 1.8v 1039.495n 1.8v 1039.505n 1.8v 1049.495n 1.8v 1049.505n 1.8v 1059.495n 1.8v 1059.505n 1.8v 1069.495n 1.8v 1069.505n 1.8v 1079.495n 1.8v 1079.505n 0.0v 1089.495n 0.0v 1089.505n 0.0v 1099.495n 0.0v 1099.505n 0.0v 1109.495n 0.0v 1109.505n 0.0v 1119.495n 0.0v 1119.505n 0.0v 1129.495n 0.0v 1129.505n 0.0v 1139.495n 0.0v 1139.505n 0.0v 1149.495n 0.0v 1149.505n 0.0v 1159.495n 0.0v 1159.505n 0.0v 1169.495n 0.0v 1169.505n 0.0v 1179.495n 0.0v 1179.505n 1.8v 1189.495n 1.8v 1189.505n 1.8v 1199.495n 1.8v 1199.505n 1.8v 1209.495n 1.8v 1209.505n 1.8v 1219.495n 1.8v 1219.505n 1.8v 1229.495n 1.8v 1229.505n 1.8v 1239.495n 1.8v 1239.505n 1.8v 1249.495n 1.8v 1249.505n 1.8v 1259.495n 1.8v 1259.505n 1.8v 1269.495n 1.8v 1269.505n 1.8v 1279.495n 1.8v 1279.505n 1.8v 1289.495n 1.8v 1289.505n 0.0v 1299.495n 0.0v 1299.505n 0.0v 1309.495n 0.0v 1309.505n 1.8v 1319.495n 1.8v 1319.505n 1.8v 1329.495n 1.8v 1329.505n 1.8v 1339.495n 1.8v 1339.505n 1.8v 1349.495n 1.8v 1349.505n 0.0v 1359.495n 0.0v 1359.505n 0.0v 1369.495n 0.0v 1369.505n 0.0v 1379.495n 0.0v 1379.505n 1.8v 1389.495n 1.8v 1389.505n 1.8v 1399.495n 1.8v 1399.505n 1.8v 1409.495n 1.8v 1409.505n 1.8v 1419.495n 1.8v 1419.505n 0.0v 1429.495n 0.0v 1429.505n 0.0v 1439.495n 0.0v 1439.505n 0.0v 1449.495n 0.0v 1449.505n 1.8v 1459.495n 1.8v 1459.505n 1.8v 1469.495n 1.8v 1469.505n 1.8v 1479.495n 1.8v 1479.505n 1.8v 1489.495n 1.8v 1489.505n 0.0v 1499.495n 0.0v 1499.505n 1.8v 1509.495n 1.8v 1509.505n 1.8v 1519.495n 1.8v 1519.505n 1.8v 1529.495n 1.8v 1529.505n 1.8v 1539.495n 1.8v 1539.505n 1.8v 1549.495n 1.8v 1549.505n 1.8v 1559.495n 1.8v 1559.505n 1.8v 1569.495n 1.8v 1569.505n 1.8v 1579.495n 1.8v 1579.505n 1.8v 1589.495n 1.8v 1589.505n 1.8v 1599.495n 1.8v 1599.505n 1.8v 1609.495n 1.8v 1609.505n 1.8v 1619.495n 1.8v 1619.505n 1.8v 1629.495n 1.8v 1629.505n 1.8v 1639.495n 1.8v 1639.505n 0.0v 1649.495n 0.0v 1649.505n 1.8v 1659.495n 1.8v 1659.505n 1.8v 1669.495n 1.8v 1669.505n 1.8v 1679.495n 1.8v 1679.505n 0.0v 1689.495n 0.0v 1689.505n 1.8v 1699.495n 1.8v 1699.505n 0.0v 1709.495n 0.0v 1709.505n 1.8v 1719.495n 1.8v 1719.505n 1.8v 1729.495n 1.8v 1729.505n 0.0v 1739.495n 0.0v 1739.505n 1.8v 1749.495n 1.8v 1749.505n 1.8v 1759.495n 1.8v 1759.505n 1.8v 1769.495n 1.8v 1769.505n 1.8v 1779.495n 1.8v 1779.505n 1.8v 1789.495n 1.8v 1789.505n 1.8v 1799.495n 1.8v 1799.505n 1.8v 1809.495n 1.8v 1809.505n 0.0v 1819.495n 0.0v 1819.505n 1.8v 1829.495n 1.8v 1829.505n 1.8v 1839.495n 1.8v 1839.505n 1.8v 1849.495n 1.8v 1849.505n 0.0v 1859.495n 0.0v 1859.505n 0.0v 1869.495n 0.0v 1869.505n 1.8v 1879.495n 1.8v 1879.505n 0.0v 1889.495n 0.0v 1889.505n 0.0v 1899.495n 0.0v 1899.505n 0.0v 1909.495n 0.0v 1909.505n 0.0v 1919.495n 0.0v 1919.505n 0.0v 1929.495n 0.0v 1929.505n 1.8v 1939.495n 1.8v 1939.505n 1.8v 1949.495n 1.8v 1949.505n 1.8v 1959.495n 1.8v 1959.505n 0.0v 1969.495n 0.0v 1969.505n 0.0v 1979.495n 0.0v 1979.505n 0.0v 1989.495n 0.0v 1989.505n 0.0v 1999.495n 0.0v 1999.505n 0.0v 2009.495n 0.0v 2009.505n 1.8v 2019.495n 1.8v 2019.505n 0.0v 2029.495n 0.0v 2029.505n 0.0v 2039.495n 0.0v 2039.505n 0.0v 2049.495n 0.0v 2049.505n 0.0v )
* (time, data): [(0, 0), (10, 0), (20, 0), (30, 0), (40, 1), (50, 1), (60, 1), (70, 1), (80, 1), (90, 1), (100, 0), (110, 0), (120, 0), (130, 1), (140, 0), (150, 0), (160, 0), (170, 0), (180, 0), (190, 1), (200, 1), (210, 1), (220, 0), (230, 1), (240, 0), (250, 0), (260, 1), (270, 1), (280, 1), (290, 0), (300, 0), (310, 0), (320, 0), (330, 0), (340, 0), (350, 0), (360, 0), (370, 0), (380, 0), (390, 0), (400, 0), (410, 0), (420, 0), (430, 0), (440, 0), (450, 0), (460, 0), (470, 1), (480, 1), (490, 1), (500, 1), (510, 1), (520, 1), (530, 0), (540, 0), (550, 0), (560, 0), (570, 0), (580, 1), (590, 1), (600, 0), (610, 0), (620, 0), (630, 0), (640, 0), (650, 0), (660, 0), (670, 0), (680, 0), (690, 1), (700, 1), (710, 1), (720, 1), (730, 1), (740, 1), (750, 1), (760, 1), (770, 1), (780, 1), (790, 0), (800, 0), (810, 0), (820, 0), (830, 0), (840, 0), (850, 0), (860, 0), (870, 0), (880, 0), (890, 0), (900, 0), (910, 0), (920, 0), (930, 0), (940, 1), (950, 1), (960, 1), (970, 1), (980, 1), (990, 0), (1000, 0), (1010, 0), (1020, 0), (1030, 0), (1040, 0), (1050, 0), (1060, 1), (1070, 1), (1080, 0), (1090, 0), (1100, 0), (1110, 1), (1120, 1), (1130, 1), (1140, 1), (1150, 1), (1160, 1), (1170, 1), (1180, 0), (1190, 0), (1200, 0), (1210, 0), (1220, 0), (1230, 0), (1240, 0), (1250, 0), (1260, 0), (1270, 0), (1280, 0), (1290, 1), (1300, 1), (1310, 0), (1320, 0), (1330, 0), (1340, 0), (1350, 0), (1360, 0), (1370, 0), (1380, 0), (1390, 0), (1400, 0), (1410, 1), (1420, 0), (1430, 1), (1440, 1), (1450, 0), (1460, 0), (1470, 0), (1480, 0), (1490, 1), (1500, 0), (1510, 0), (1520, 0), (1530, 0), (1540, 0), (1550, 0), (1560, 0), (1570, 0), (1580, 0), (1590, 0), (1600, 0), (1610, 0), (1620, 0), (1630, 0), (1640, 0), (1650, 0), (1660, 0), (1670, 0), (1680, 1), (1690, 0), (1700, 0), (1710, 0), (1720, 0), (1730, 1), (1740, 0), (1750, 0), (1760, 0), (1770, 0), (1780, 0), (1790, 0), (1800, 0), (1810, 1), (1820, 0), (1830, 0), (1840, 1), (1850, 1), (1860, 1), (1870, 0), (1880, 0), (1890, 0), (1900, 0), (1910, 0), (1920, 0), (1930, 0), (1940, 0), (1950, 0), (1960, 1), (1970, 1), (1980, 1), (1990, 1), (2000, 1), (2010, 0), (2020, 0), (2030, 0), (2040, 0), (2050, 0)]
Va1_2  a1_2  0 PWL (0n 0.0v 9.495n 0.0v 9.505n 0.0v 19.495n 0.0v 19.505n 0.0v 29.495n 0.0v 29.505n 0.0v 39.495n 0.0v 39.505n 1.8v 49.495n 1.8v 49.505n 1.8v 59.495n 1.8v 59.505n 1.8v 69.495n 1.8v 69.505n 1.8v 79.495n 1.8v 79.505n 1.8v 89.495n 1.8v 89.505n 1.8v 99.495n 1.8v 99.505n 0.0v 109.495n 0.0v 109.505n 0.0v 119.495n 0.0v 119.505n 0.0v 129.495n 0.0v 129.505n 1.8v 139.495n 1.8v 139.505n 0.0v 149.495n 0.0v 149.505n 0.0v 159.495n 0.0v 159.505n 0.0v 169.495n 0.0v 169.505n 0.0v 179.495n 0.0v 179.505n 0.0v 189.495n 0.0v 189.505n 1.8v 199.495n 1.8v 199.505n 1.8v 209.495n 1.8v 209.505n 1.8v 219.495n 1.8v 219.505n 0.0v 229.495n 0.0v 229.505n 1.8v 239.495n 1.8v 239.505n 0.0v 249.495n 0.0v 249.505n 0.0v 259.495n 0.0v 259.505n 1.8v 269.495n 1.8v 269.505n 1.8v 279.495n 1.8v 279.505n 1.8v 289.495n 1.8v 289.505n 0.0v 299.495n 0.0v 299.505n 0.0v 309.495n 0.0v 309.505n 0.0v 319.495n 0.0v 319.505n 0.0v 329.495n 0.0v 329.505n 0.0v 339.495n 0.0v 339.505n 0.0v 349.495n 0.0v 349.505n 0.0v 359.495n 0.0v 359.505n 0.0v 369.495n 0.0v 369.505n 0.0v 379.495n 0.0v 379.505n 0.0v 389.495n 0.0v 389.505n 0.0v 399.495n 0.0v 399.505n 0.0v 409.495n 0.0v 409.505n 0.0v 419.495n 0.0v 419.505n 0.0v 429.495n 0.0v 429.505n 0.0v 439.495n 0.0v 439.505n 0.0v 449.495n 0.0v 449.505n 0.0v 459.495n 0.0v 459.505n 0.0v 469.495n 0.0v 469.505n 1.8v 479.495n 1.8v 479.505n 1.8v 489.495n 1.8v 489.505n 1.8v 499.495n 1.8v 499.505n 1.8v 509.495n 1.8v 509.505n 1.8v 519.495n 1.8v 519.505n 1.8v 529.495n 1.8v 529.505n 0.0v 539.495n 0.0v 539.505n 0.0v 549.495n 0.0v 549.505n 0.0v 559.495n 0.0v 559.505n 0.0v 569.495n 0.0v 569.505n 0.0v 579.495n 0.0v 579.505n 1.8v 589.495n 1.8v 589.505n 1.8v 599.495n 1.8v 599.505n 0.0v 609.495n 0.0v 609.505n 0.0v 619.495n 0.0v 619.505n 0.0v 629.495n 0.0v 629.505n 0.0v 639.495n 0.0v 639.505n 0.0v 649.495n 0.0v 649.505n 0.0v 659.495n 0.0v 659.505n 0.0v 669.495n 0.0v 669.505n 0.0v 679.495n 0.0v 679.505n 0.0v 689.495n 0.0v 689.505n 1.8v 699.495n 1.8v 699.505n 1.8v 709.495n 1.8v 709.505n 1.8v 719.495n 1.8v 719.505n 1.8v 729.495n 1.8v 729.505n 1.8v 739.495n 1.8v 739.505n 1.8v 749.495n 1.8v 749.505n 1.8v 759.495n 1.8v 759.505n 1.8v 769.495n 1.8v 769.505n 1.8v 779.495n 1.8v 779.505n 1.8v 789.495n 1.8v 789.505n 0.0v 799.495n 0.0v 799.505n 0.0v 809.495n 0.0v 809.505n 0.0v 819.495n 0.0v 819.505n 0.0v 829.495n 0.0v 829.505n 0.0v 839.495n 0.0v 839.505n 0.0v 849.495n 0.0v 849.505n 0.0v 859.495n 0.0v 859.505n 0.0v 869.495n 0.0v 869.505n 0.0v 879.495n 0.0v 879.505n 0.0v 889.495n 0.0v 889.505n 0.0v 899.495n 0.0v 899.505n 0.0v 909.495n 0.0v 909.505n 0.0v 919.495n 0.0v 919.505n 0.0v 929.495n 0.0v 929.505n 0.0v 939.495n 0.0v 939.505n 1.8v 949.495n 1.8v 949.505n 1.8v 959.495n 1.8v 959.505n 1.8v 969.495n 1.8v 969.505n 1.8v 979.495n 1.8v 979.505n 1.8v 989.495n 1.8v 989.505n 0.0v 999.495n 0.0v 999.505n 0.0v 1009.495n 0.0v 1009.505n 0.0v 1019.495n 0.0v 1019.505n 0.0v 1029.495n 0.0v 1029.505n 0.0v 1039.495n 0.0v 1039.505n 0.0v 1049.495n 0.0v 1049.505n 0.0v 1059.495n 0.0v 1059.505n 1.8v 1069.495n 1.8v 1069.505n 1.8v 1079.495n 1.8v 1079.505n 0.0v 1089.495n 0.0v 1089.505n 0.0v 1099.495n 0.0v 1099.505n 0.0v 1109.495n 0.0v 1109.505n 1.8v 1119.495n 1.8v 1119.505n 1.8v 1129.495n 1.8v 1129.505n 1.8v 1139.495n 1.8v 1139.505n 1.8v 1149.495n 1.8v 1149.505n 1.8v 1159.495n 1.8v 1159.505n 1.8v 1169.495n 1.8v 1169.505n 1.8v 1179.495n 1.8v 1179.505n 0.0v 1189.495n 0.0v 1189.505n 0.0v 1199.495n 0.0v 1199.505n 0.0v 1209.495n 0.0v 1209.505n 0.0v 1219.495n 0.0v 1219.505n 0.0v 1229.495n 0.0v 1229.505n 0.0v 1239.495n 0.0v 1239.505n 0.0v 1249.495n 0.0v 1249.505n 0.0v 1259.495n 0.0v 1259.505n 0.0v 1269.495n 0.0v 1269.505n 0.0v 1279.495n 0.0v 1279.505n 0.0v 1289.495n 0.0v 1289.505n 1.8v 1299.495n 1.8v 1299.505n 1.8v 1309.495n 1.8v 1309.505n 0.0v 1319.495n 0.0v 1319.505n 0.0v 1329.495n 0.0v 1329.505n 0.0v 1339.495n 0.0v 1339.505n 0.0v 1349.495n 0.0v 1349.505n 0.0v 1359.495n 0.0v 1359.505n 0.0v 1369.495n 0.0v 1369.505n 0.0v 1379.495n 0.0v 1379.505n 0.0v 1389.495n 0.0v 1389.505n 0.0v 1399.495n 0.0v 1399.505n 0.0v 1409.495n 0.0v 1409.505n 1.8v 1419.495n 1.8v 1419.505n 0.0v 1429.495n 0.0v 1429.505n 1.8v 1439.495n 1.8v 1439.505n 1.8v 1449.495n 1.8v 1449.505n 0.0v 1459.495n 0.0v 1459.505n 0.0v 1469.495n 0.0v 1469.505n 0.0v 1479.495n 0.0v 1479.505n 0.0v 1489.495n 0.0v 1489.505n 1.8v 1499.495n 1.8v 1499.505n 0.0v 1509.495n 0.0v 1509.505n 0.0v 1519.495n 0.0v 1519.505n 0.0v 1529.495n 0.0v 1529.505n 0.0v 1539.495n 0.0v 1539.505n 0.0v 1549.495n 0.0v 1549.505n 0.0v 1559.495n 0.0v 1559.505n 0.0v 1569.495n 0.0v 1569.505n 0.0v 1579.495n 0.0v 1579.505n 0.0v 1589.495n 0.0v 1589.505n 0.0v 1599.495n 0.0v 1599.505n 0.0v 1609.495n 0.0v 1609.505n 0.0v 1619.495n 0.0v 1619.505n 0.0v 1629.495n 0.0v 1629.505n 0.0v 1639.495n 0.0v 1639.505n 0.0v 1649.495n 0.0v 1649.505n 0.0v 1659.495n 0.0v 1659.505n 0.0v 1669.495n 0.0v 1669.505n 0.0v 1679.495n 0.0v 1679.505n 1.8v 1689.495n 1.8v 1689.505n 0.0v 1699.495n 0.0v 1699.505n 0.0v 1709.495n 0.0v 1709.505n 0.0v 1719.495n 0.0v 1719.505n 0.0v 1729.495n 0.0v 1729.505n 1.8v 1739.495n 1.8v 1739.505n 0.0v 1749.495n 0.0v 1749.505n 0.0v 1759.495n 0.0v 1759.505n 0.0v 1769.495n 0.0v 1769.505n 0.0v 1779.495n 0.0v 1779.505n 0.0v 1789.495n 0.0v 1789.505n 0.0v 1799.495n 0.0v 1799.505n 0.0v 1809.495n 0.0v 1809.505n 1.8v 1819.495n 1.8v 1819.505n 0.0v 1829.495n 0.0v 1829.505n 0.0v 1839.495n 0.0v 1839.505n 1.8v 1849.495n 1.8v 1849.505n 1.8v 1859.495n 1.8v 1859.505n 1.8v 1869.495n 1.8v 1869.505n 0.0v 1879.495n 0.0v 1879.505n 0.0v 1889.495n 0.0v 1889.505n 0.0v 1899.495n 0.0v 1899.505n 0.0v 1909.495n 0.0v 1909.505n 0.0v 1919.495n 0.0v 1919.505n 0.0v 1929.495n 0.0v 1929.505n 0.0v 1939.495n 0.0v 1939.505n 0.0v 1949.495n 0.0v 1949.505n 0.0v 1959.495n 0.0v 1959.505n 1.8v 1969.495n 1.8v 1969.505n 1.8v 1979.495n 1.8v 1979.505n 1.8v 1989.495n 1.8v 1989.505n 1.8v 1999.495n 1.8v 1999.505n 1.8v 2009.495n 1.8v 2009.505n 0.0v 2019.495n 0.0v 2019.505n 0.0v 2029.495n 0.0v 2029.505n 0.0v 2039.495n 0.0v 2039.505n 0.0v 2049.495n 0.0v 2049.505n 0.0v )
* (time, data): [(0, 0), (10, 0), (20, 0), (30, 0), (40, 1), (50, 1), (60, 1), (70, 1), (80, 1), (90, 1), (100, 0), (110, 0), (120, 0), (130, 1), (140, 0), (150, 0), (160, 1), (170, 1), (180, 1), (190, 1), (200, 1), (210, 1), (220, 1), (230, 1), (240, 0), (250, 0), (260, 1), (270, 1), (280, 1), (290, 0), (300, 0), (310, 0), (320, 0), (330, 0), (340, 1), (350, 1), (360, 1), (370, 1), (380, 0), (390, 0), (400, 1), (410, 1), (420, 1), (430, 0), (440, 0), (450, 0), (460, 0), (470, 1), (480, 1), (490, 1), (500, 1), (510, 1), (520, 1), (530, 0), (540, 0), (550, 0), (560, 0), (570, 0), (580, 1), (590, 1), (600, 0), (610, 0), (620, 0), (630, 0), (640, 0), (650, 0), (660, 0), (670, 0), (680, 0), (690, 1), (700, 1), (710, 1), (720, 1), (730, 1), (740, 1), (750, 1), (760, 1), (770, 1), (780, 1), (790, 0), (800, 0), (810, 0), (820, 1), (830, 0), (840, 0), (850, 0), (860, 1), (870, 1), (880, 1), (890, 1), (900, 1), (910, 0), (920, 0), (930, 0), (940, 1), (950, 1), (960, 1), (970, 1), (980, 1), (990, 1), (1000, 1), (1010, 1), (1020, 1), (1030, 1), (1040, 0), (1050, 0), (1060, 1), (1070, 1), (1080, 0), (1090, 0), (1100, 0), (1110, 1), (1120, 1), (1130, 1), (1140, 1), (1150, 1), (1160, 1), (1170, 1), (1180, 0), (1190, 0), (1200, 0), (1210, 0), (1220, 0), (1230, 0), (1240, 0), (1250, 0), (1260, 0), (1270, 0), (1280, 0), (1290, 1), (1300, 1), (1310, 0), (1320, 0), (1330, 0), (1340, 0), (1350, 0), (1360, 0), (1370, 0), (1380, 0), (1390, 0), (1400, 0), (1410, 1), (1420, 0), (1430, 1), (1440, 1), (1450, 1), (1460, 1), (1470, 1), (1480, 1), (1490, 1), (1500, 1), (1510, 1), (1520, 1), (1530, 1), (1540, 1), (1550, 1), (1560, 0), (1570, 0), (1580, 0), (1590, 0), (1600, 0), (1610, 0), (1620, 0), (1630, 0), (1640, 0), (1650, 0), (1660, 0), (1670, 0), (1680, 1), (1690, 1), (1700, 0), (1710, 0), (1720, 0), (1730, 1), (1740, 0), (1750, 0), (1760, 0), (1770, 0), (1780, 0), (1790, 0), (1800, 1), (1810, 1), (1820, 0), (1830, 0), (1840, 1), (1850, 1), (1860, 1), (1870, 0), (1880, 0), (1890, 0), (1900, 0), (1910, 0), (1920, 0), (1930, 0), (1940, 0), (1950, 0), (1960, 1), (1970, 1), (1980, 1), (1990, 1), (2000, 1), (2010, 0), (2020, 0), (2030, 0), (2040, 0), (2050, 0)]
Va1_3  a1_3  0 PWL (0n 0.0v 9.495n 0.0v 9.505n 0.0v 19.495n 0.0v 19.505n 0.0v 29.495n 0.0v 29.505n 0.0v 39.495n 0.0v 39.505n 1.8v 49.495n 1.8v 49.505n 1.8v 59.495n 1.8v 59.505n 1.8v 69.495n 1.8v 69.505n 1.8v 79.495n 1.8v 79.505n 1.8v 89.495n 1.8v 89.505n 1.8v 99.495n 1.8v 99.505n 0.0v 109.495n 0.0v 109.505n 0.0v 119.495n 0.0v 119.505n 0.0v 129.495n 0.0v 129.505n 1.8v 139.495n 1.8v 139.505n 0.0v 149.495n 0.0v 149.505n 0.0v 159.495n 0.0v 159.505n 1.8v 169.495n 1.8v 169.505n 1.8v 179.495n 1.8v 179.505n 1.8v 189.495n 1.8v 189.505n 1.8v 199.495n 1.8v 199.505n 1.8v 209.495n 1.8v 209.505n 1.8v 219.495n 1.8v 219.505n 1.8v 229.495n 1.8v 229.505n 1.8v 239.495n 1.8v 239.505n 0.0v 249.495n 0.0v 249.505n 0.0v 259.495n 0.0v 259.505n 1.8v 269.495n 1.8v 269.505n 1.8v 279.495n 1.8v 279.505n 1.8v 289.495n 1.8v 289.505n 0.0v 299.495n 0.0v 299.505n 0.0v 309.495n 0.0v 309.505n 0.0v 319.495n 0.0v 319.505n 0.0v 329.495n 0.0v 329.505n 0.0v 339.495n 0.0v 339.505n 1.8v 349.495n 1.8v 349.505n 1.8v 359.495n 1.8v 359.505n 1.8v 369.495n 1.8v 369.505n 1.8v 379.495n 1.8v 379.505n 0.0v 389.495n 0.0v 389.505n 0.0v 399.495n 0.0v 399.505n 1.8v 409.495n 1.8v 409.505n 1.8v 419.495n 1.8v 419.505n 1.8v 429.495n 1.8v 429.505n 0.0v 439.495n 0.0v 439.505n 0.0v 449.495n 0.0v 449.505n 0.0v 459.495n 0.0v 459.505n 0.0v 469.495n 0.0v 469.505n 1.8v 479.495n 1.8v 479.505n 1.8v 489.495n 1.8v 489.505n 1.8v 499.495n 1.8v 499.505n 1.8v 509.495n 1.8v 509.505n 1.8v 519.495n 1.8v 519.505n 1.8v 529.495n 1.8v 529.505n 0.0v 539.495n 0.0v 539.505n 0.0v 549.495n 0.0v 549.505n 0.0v 559.495n 0.0v 559.505n 0.0v 569.495n 0.0v 569.505n 0.0v 579.495n 0.0v 579.505n 1.8v 589.495n 1.8v 589.505n 1.8v 599.495n 1.8v 599.505n 0.0v 609.495n 0.0v 609.505n 0.0v 619.495n 0.0v 619.505n 0.0v 629.495n 0.0v 629.505n 0.0v 639.495n 0.0v 639.505n 0.0v 649.495n 0.0v 649.505n 0.0v 659.495n 0.0v 659.505n 0.0v 669.495n 0.0v 669.505n 0.0v 679.495n 0.0v 679.505n 0.0v 689.495n 0.0v 689.505n 1.8v 699.495n 1.8v 699.505n 1.8v 709.495n 1.8v 709.505n 1.8v 719.495n 1.8v 719.505n 1.8v 729.495n 1.8v 729.505n 1.8v 739.495n 1.8v 739.505n 1.8v 749.495n 1.8v 749.505n 1.8v 759.495n 1.8v 759.505n 1.8v 769.495n 1.8v 769.505n 1.8v 779.495n 1.8v 779.505n 1.8v 789.495n 1.8v 789.505n 0.0v 799.495n 0.0v 799.505n 0.0v 809.495n 0.0v 809.505n 0.0v 819.495n 0.0v 819.505n 1.8v 829.495n 1.8v 829.505n 0.0v 839.495n 0.0v 839.505n 0.0v 849.495n 0.0v 849.505n 0.0v 859.495n 0.0v 859.505n 1.8v 869.495n 1.8v 869.505n 1.8v 879.495n 1.8v 879.505n 1.8v 889.495n 1.8v 889.505n 1.8v 899.495n 1.8v 899.505n 1.8v 909.495n 1.8v 909.505n 0.0v 919.495n 0.0v 919.505n 0.0v 929.495n 0.0v 929.505n 0.0v 939.495n 0.0v 939.505n 1.8v 949.495n 1.8v 949.505n 1.8v 959.495n 1.8v 959.505n 1.8v 969.495n 1.8v 969.505n 1.8v 979.495n 1.8v 979.505n 1.8v 989.495n 1.8v 989.505n 1.8v 999.495n 1.8v 999.505n 1.8v 1009.495n 1.8v 1009.505n 1.8v 1019.495n 1.8v 1019.505n 1.8v 1029.495n 1.8v 1029.505n 1.8v 1039.495n 1.8v 1039.505n 0.0v 1049.495n 0.0v 1049.505n 0.0v 1059.495n 0.0v 1059.505n 1.8v 1069.495n 1.8v 1069.505n 1.8v 1079.495n 1.8v 1079.505n 0.0v 1089.495n 0.0v 1089.505n 0.0v 1099.495n 0.0v 1099.505n 0.0v 1109.495n 0.0v 1109.505n 1.8v 1119.495n 1.8v 1119.505n 1.8v 1129.495n 1.8v 1129.505n 1.8v 1139.495n 1.8v 1139.505n 1.8v 1149.495n 1.8v 1149.505n 1.8v 1159.495n 1.8v 1159.505n 1.8v 1169.495n 1.8v 1169.505n 1.8v 1179.495n 1.8v 1179.505n 0.0v 1189.495n 0.0v 1189.505n 0.0v 1199.495n 0.0v 1199.505n 0.0v 1209.495n 0.0v 1209.505n 0.0v 1219.495n 0.0v 1219.505n 0.0v 1229.495n 0.0v 1229.505n 0.0v 1239.495n 0.0v 1239.505n 0.0v 1249.495n 0.0v 1249.505n 0.0v 1259.495n 0.0v 1259.505n 0.0v 1269.495n 0.0v 1269.505n 0.0v 1279.495n 0.0v 1279.505n 0.0v 1289.495n 0.0v 1289.505n 1.8v 1299.495n 1.8v 1299.505n 1.8v 1309.495n 1.8v 1309.505n 0.0v 1319.495n 0.0v 1319.505n 0.0v 1329.495n 0.0v 1329.505n 0.0v 1339.495n 0.0v 1339.505n 0.0v 1349.495n 0.0v 1349.505n 0.0v 1359.495n 0.0v 1359.505n 0.0v 1369.495n 0.0v 1369.505n 0.0v 1379.495n 0.0v 1379.505n 0.0v 1389.495n 0.0v 1389.505n 0.0v 1399.495n 0.0v 1399.505n 0.0v 1409.495n 0.0v 1409.505n 1.8v 1419.495n 1.8v 1419.505n 0.0v 1429.495n 0.0v 1429.505n 1.8v 1439.495n 1.8v 1439.505n 1.8v 1449.495n 1.8v 1449.505n 1.8v 1459.495n 1.8v 1459.505n 1.8v 1469.495n 1.8v 1469.505n 1.8v 1479.495n 1.8v 1479.505n 1.8v 1489.495n 1.8v 1489.505n 1.8v 1499.495n 1.8v 1499.505n 1.8v 1509.495n 1.8v 1509.505n 1.8v 1519.495n 1.8v 1519.505n 1.8v 1529.495n 1.8v 1529.505n 1.8v 1539.495n 1.8v 1539.505n 1.8v 1549.495n 1.8v 1549.505n 1.8v 1559.495n 1.8v 1559.505n 0.0v 1569.495n 0.0v 1569.505n 0.0v 1579.495n 0.0v 1579.505n 0.0v 1589.495n 0.0v 1589.505n 0.0v 1599.495n 0.0v 1599.505n 0.0v 1609.495n 0.0v 1609.505n 0.0v 1619.495n 0.0v 1619.505n 0.0v 1629.495n 0.0v 1629.505n 0.0v 1639.495n 0.0v 1639.505n 0.0v 1649.495n 0.0v 1649.505n 0.0v 1659.495n 0.0v 1659.505n 0.0v 1669.495n 0.0v 1669.505n 0.0v 1679.495n 0.0v 1679.505n 1.8v 1689.495n 1.8v 1689.505n 1.8v 1699.495n 1.8v 1699.505n 0.0v 1709.495n 0.0v 1709.505n 0.0v 1719.495n 0.0v 1719.505n 0.0v 1729.495n 0.0v 1729.505n 1.8v 1739.495n 1.8v 1739.505n 0.0v 1749.495n 0.0v 1749.505n 0.0v 1759.495n 0.0v 1759.505n 0.0v 1769.495n 0.0v 1769.505n 0.0v 1779.495n 0.0v 1779.505n 0.0v 1789.495n 0.0v 1789.505n 0.0v 1799.495n 0.0v 1799.505n 1.8v 1809.495n 1.8v 1809.505n 1.8v 1819.495n 1.8v 1819.505n 0.0v 1829.495n 0.0v 1829.505n 0.0v 1839.495n 0.0v 1839.505n 1.8v 1849.495n 1.8v 1849.505n 1.8v 1859.495n 1.8v 1859.505n 1.8v 1869.495n 1.8v 1869.505n 0.0v 1879.495n 0.0v 1879.505n 0.0v 1889.495n 0.0v 1889.505n 0.0v 1899.495n 0.0v 1899.505n 0.0v 1909.495n 0.0v 1909.505n 0.0v 1919.495n 0.0v 1919.505n 0.0v 1929.495n 0.0v 1929.505n 0.0v 1939.495n 0.0v 1939.505n 0.0v 1949.495n 0.0v 1949.505n 0.0v 1959.495n 0.0v 1959.505n 1.8v 1969.495n 1.8v 1969.505n 1.8v 1979.495n 1.8v 1979.505n 1.8v 1989.495n 1.8v 1989.505n 1.8v 1999.495n 1.8v 1999.505n 1.8v 2009.495n 1.8v 2009.505n 0.0v 2019.495n 0.0v 2019.505n 0.0v 2029.495n 0.0v 2029.505n 0.0v 2039.495n 0.0v 2039.505n 0.0v 2049.495n 0.0v 2049.505n 0.0v )
* (time, data): [(0, 0), (10, 0), (20, 0), (30, 0), (40, 1), (50, 1), (60, 1), (70, 1), (80, 1), (90, 1), (100, 0), (110, 0), (120, 0), (130, 1), (140, 0), (150, 0), (160, 1), (170, 1), (180, 1), (190, 1), (200, 1), (210, 1), (220, 1), (230, 1), (240, 0), (250, 0), (260, 1), (270, 1), (280, 1), (290, 0), (300, 0), (310, 0), (320, 0), (330, 0), (340, 1), (350, 1), (360, 1), (370, 1), (380, 0), (390, 0), (400, 1), (410, 1), (420, 1), (430, 0), (440, 0), (450, 0), (460, 0), (470, 1), (480, 1), (490, 1), (500, 1), (510, 1), (520, 1), (530, 0), (540, 0), (550, 0), (560, 0), (570, 0), (580, 1), (590, 1), (600, 0), (610, 0), (620, 0), (630, 0), (640, 0), (650, 0), (660, 0), (670, 0), (680, 0), (690, 1), (700, 1), (710, 1), (720, 1), (730, 1), (740, 1), (750, 1), (760, 1), (770, 1), (780, 1), (790, 0), (800, 0), (810, 0), (820, 1), (830, 0), (840, 0), (850, 0), (860, 1), (870, 1), (880, 1), (890, 1), (900, 1), (910, 0), (920, 0), (930, 0), (940, 1), (950, 1), (960, 1), (970, 1), (980, 1), (990, 1), (1000, 1), (1010, 1), (1020, 1), (1030, 1), (1040, 0), (1050, 0), (1060, 1), (1070, 1), (1080, 0), (1090, 0), (1100, 0), (1110, 1), (1120, 1), (1130, 1), (1140, 1), (1150, 1), (1160, 1), (1170, 1), (1180, 0), (1190, 0), (1200, 0), (1210, 0), (1220, 0), (1230, 0), (1240, 0), (1250, 0), (1260, 0), (1270, 0), (1280, 0), (1290, 1), (1300, 1), (1310, 0), (1320, 0), (1330, 0), (1340, 0), (1350, 0), (1360, 0), (1370, 0), (1380, 0), (1390, 0), (1400, 0), (1410, 1), (1420, 0), (1430, 1), (1440, 1), (1450, 1), (1460, 1), (1470, 1), (1480, 1), (1490, 1), (1500, 1), (1510, 1), (1520, 1), (1530, 1), (1540, 1), (1550, 1), (1560, 0), (1570, 0), (1580, 0), (1590, 0), (1600, 0), (1610, 0), (1620, 0), (1630, 0), (1640, 0), (1650, 0), (1660, 0), (1670, 0), (1680, 1), (1690, 1), (1700, 0), (1710, 0), (1720, 0), (1730, 1), (1740, 0), (1750, 0), (1760, 0), (1770, 0), (1780, 0), (1790, 0), (1800, 1), (1810, 1), (1820, 0), (1830, 0), (1840, 1), (1850, 1), (1860, 1), (1870, 0), (1880, 0), (1890, 0), (1900, 0), (1910, 0), (1920, 0), (1930, 0), (1940, 0), (1950, 0), (1960, 1), (1970, 1), (1980, 1), (1990, 1), (2000, 1), (2010, 0), (2020, 0), (2030, 0), (2040, 0), (2050, 0)]
Va1_4  a1_4  0 PWL (0n 0.0v 9.495n 0.0v 9.505n 0.0v 19.495n 0.0v 19.505n 0.0v 29.495n 0.0v 29.505n 0.0v 39.495n 0.0v 39.505n 1.8v 49.495n 1.8v 49.505n 1.8v 59.495n 1.8v 59.505n 1.8v 69.495n 1.8v 69.505n 1.8v 79.495n 1.8v 79.505n 1.8v 89.495n 1.8v 89.505n 1.8v 99.495n 1.8v 99.505n 0.0v 109.495n 0.0v 109.505n 0.0v 119.495n 0.0v 119.505n 0.0v 129.495n 0.0v 129.505n 1.8v 139.495n 1.8v 139.505n 0.0v 149.495n 0.0v 149.505n 0.0v 159.495n 0.0v 159.505n 1.8v 169.495n 1.8v 169.505n 1.8v 179.495n 1.8v 179.505n 1.8v 189.495n 1.8v 189.505n 1.8v 199.495n 1.8v 199.505n 1.8v 209.495n 1.8v 209.505n 1.8v 219.495n 1.8v 219.505n 1.8v 229.495n 1.8v 229.505n 1.8v 239.495n 1.8v 239.505n 0.0v 249.495n 0.0v 249.505n 0.0v 259.495n 0.0v 259.505n 1.8v 269.495n 1.8v 269.505n 1.8v 279.495n 1.8v 279.505n 1.8v 289.495n 1.8v 289.505n 0.0v 299.495n 0.0v 299.505n 0.0v 309.495n 0.0v 309.505n 0.0v 319.495n 0.0v 319.505n 0.0v 329.495n 0.0v 329.505n 0.0v 339.495n 0.0v 339.505n 1.8v 349.495n 1.8v 349.505n 1.8v 359.495n 1.8v 359.505n 1.8v 369.495n 1.8v 369.505n 1.8v 379.495n 1.8v 379.505n 0.0v 389.495n 0.0v 389.505n 0.0v 399.495n 0.0v 399.505n 1.8v 409.495n 1.8v 409.505n 1.8v 419.495n 1.8v 419.505n 1.8v 429.495n 1.8v 429.505n 0.0v 439.495n 0.0v 439.505n 0.0v 449.495n 0.0v 449.505n 0.0v 459.495n 0.0v 459.505n 0.0v 469.495n 0.0v 469.505n 1.8v 479.495n 1.8v 479.505n 1.8v 489.495n 1.8v 489.505n 1.8v 499.495n 1.8v 499.505n 1.8v 509.495n 1.8v 509.505n 1.8v 519.495n 1.8v 519.505n 1.8v 529.495n 1.8v 529.505n 0.0v 539.495n 0.0v 539.505n 0.0v 549.495n 0.0v 549.505n 0.0v 559.495n 0.0v 559.505n 0.0v 569.495n 0.0v 569.505n 0.0v 579.495n 0.0v 579.505n 1.8v 589.495n 1.8v 589.505n 1.8v 599.495n 1.8v 599.505n 0.0v 609.495n 0.0v 609.505n 0.0v 619.495n 0.0v 619.505n 0.0v 629.495n 0.0v 629.505n 0.0v 639.495n 0.0v 639.505n 0.0v 649.495n 0.0v 649.505n 0.0v 659.495n 0.0v 659.505n 0.0v 669.495n 0.0v 669.505n 0.0v 679.495n 0.0v 679.505n 0.0v 689.495n 0.0v 689.505n 1.8v 699.495n 1.8v 699.505n 1.8v 709.495n 1.8v 709.505n 1.8v 719.495n 1.8v 719.505n 1.8v 729.495n 1.8v 729.505n 1.8v 739.495n 1.8v 739.505n 1.8v 749.495n 1.8v 749.505n 1.8v 759.495n 1.8v 759.505n 1.8v 769.495n 1.8v 769.505n 1.8v 779.495n 1.8v 779.505n 1.8v 789.495n 1.8v 789.505n 0.0v 799.495n 0.0v 799.505n 0.0v 809.495n 0.0v 809.505n 0.0v 819.495n 0.0v 819.505n 1.8v 829.495n 1.8v 829.505n 0.0v 839.495n 0.0v 839.505n 0.0v 849.495n 0.0v 849.505n 0.0v 859.495n 0.0v 859.505n 1.8v 869.495n 1.8v 869.505n 1.8v 879.495n 1.8v 879.505n 1.8v 889.495n 1.8v 889.505n 1.8v 899.495n 1.8v 899.505n 1.8v 909.495n 1.8v 909.505n 0.0v 919.495n 0.0v 919.505n 0.0v 929.495n 0.0v 929.505n 0.0v 939.495n 0.0v 939.505n 1.8v 949.495n 1.8v 949.505n 1.8v 959.495n 1.8v 959.505n 1.8v 969.495n 1.8v 969.505n 1.8v 979.495n 1.8v 979.505n 1.8v 989.495n 1.8v 989.505n 1.8v 999.495n 1.8v 999.505n 1.8v 1009.495n 1.8v 1009.505n 1.8v 1019.495n 1.8v 1019.505n 1.8v 1029.495n 1.8v 1029.505n 1.8v 1039.495n 1.8v 1039.505n 0.0v 1049.495n 0.0v 1049.505n 0.0v 1059.495n 0.0v 1059.505n 1.8v 1069.495n 1.8v 1069.505n 1.8v 1079.495n 1.8v 1079.505n 0.0v 1089.495n 0.0v 1089.505n 0.0v 1099.495n 0.0v 1099.505n 0.0v 1109.495n 0.0v 1109.505n 1.8v 1119.495n 1.8v 1119.505n 1.8v 1129.495n 1.8v 1129.505n 1.8v 1139.495n 1.8v 1139.505n 1.8v 1149.495n 1.8v 1149.505n 1.8v 1159.495n 1.8v 1159.505n 1.8v 1169.495n 1.8v 1169.505n 1.8v 1179.495n 1.8v 1179.505n 0.0v 1189.495n 0.0v 1189.505n 0.0v 1199.495n 0.0v 1199.505n 0.0v 1209.495n 0.0v 1209.505n 0.0v 1219.495n 0.0v 1219.505n 0.0v 1229.495n 0.0v 1229.505n 0.0v 1239.495n 0.0v 1239.505n 0.0v 1249.495n 0.0v 1249.505n 0.0v 1259.495n 0.0v 1259.505n 0.0v 1269.495n 0.0v 1269.505n 0.0v 1279.495n 0.0v 1279.505n 0.0v 1289.495n 0.0v 1289.505n 1.8v 1299.495n 1.8v 1299.505n 1.8v 1309.495n 1.8v 1309.505n 0.0v 1319.495n 0.0v 1319.505n 0.0v 1329.495n 0.0v 1329.505n 0.0v 1339.495n 0.0v 1339.505n 0.0v 1349.495n 0.0v 1349.505n 0.0v 1359.495n 0.0v 1359.505n 0.0v 1369.495n 0.0v 1369.505n 0.0v 1379.495n 0.0v 1379.505n 0.0v 1389.495n 0.0v 1389.505n 0.0v 1399.495n 0.0v 1399.505n 0.0v 1409.495n 0.0v 1409.505n 1.8v 1419.495n 1.8v 1419.505n 0.0v 1429.495n 0.0v 1429.505n 1.8v 1439.495n 1.8v 1439.505n 1.8v 1449.495n 1.8v 1449.505n 1.8v 1459.495n 1.8v 1459.505n 1.8v 1469.495n 1.8v 1469.505n 1.8v 1479.495n 1.8v 1479.505n 1.8v 1489.495n 1.8v 1489.505n 1.8v 1499.495n 1.8v 1499.505n 1.8v 1509.495n 1.8v 1509.505n 1.8v 1519.495n 1.8v 1519.505n 1.8v 1529.495n 1.8v 1529.505n 1.8v 1539.495n 1.8v 1539.505n 1.8v 1549.495n 1.8v 1549.505n 1.8v 1559.495n 1.8v 1559.505n 0.0v 1569.495n 0.0v 1569.505n 0.0v 1579.495n 0.0v 1579.505n 0.0v 1589.495n 0.0v 1589.505n 0.0v 1599.495n 0.0v 1599.505n 0.0v 1609.495n 0.0v 1609.505n 0.0v 1619.495n 0.0v 1619.505n 0.0v 1629.495n 0.0v 1629.505n 0.0v 1639.495n 0.0v 1639.505n 0.0v 1649.495n 0.0v 1649.505n 0.0v 1659.495n 0.0v 1659.505n 0.0v 1669.495n 0.0v 1669.505n 0.0v 1679.495n 0.0v 1679.505n 1.8v 1689.495n 1.8v 1689.505n 1.8v 1699.495n 1.8v 1699.505n 0.0v 1709.495n 0.0v 1709.505n 0.0v 1719.495n 0.0v 1719.505n 0.0v 1729.495n 0.0v 1729.505n 1.8v 1739.495n 1.8v 1739.505n 0.0v 1749.495n 0.0v 1749.505n 0.0v 1759.495n 0.0v 1759.505n 0.0v 1769.495n 0.0v 1769.505n 0.0v 1779.495n 0.0v 1779.505n 0.0v 1789.495n 0.0v 1789.505n 0.0v 1799.495n 0.0v 1799.505n 1.8v 1809.495n 1.8v 1809.505n 1.8v 1819.495n 1.8v 1819.505n 0.0v 1829.495n 0.0v 1829.505n 0.0v 1839.495n 0.0v 1839.505n 1.8v 1849.495n 1.8v 1849.505n 1.8v 1859.495n 1.8v 1859.505n 1.8v 1869.495n 1.8v 1869.505n 0.0v 1879.495n 0.0v 1879.505n 0.0v 1889.495n 0.0v 1889.505n 0.0v 1899.495n 0.0v 1899.505n 0.0v 1909.495n 0.0v 1909.505n 0.0v 1919.495n 0.0v 1919.505n 0.0v 1929.495n 0.0v 1929.505n 0.0v 1939.495n 0.0v 1939.505n 0.0v 1949.495n 0.0v 1949.505n 0.0v 1959.495n 0.0v 1959.505n 1.8v 1969.495n 1.8v 1969.505n 1.8v 1979.495n 1.8v 1979.505n 1.8v 1989.495n 1.8v 1989.505n 1.8v 1999.495n 1.8v 1999.505n 1.8v 2009.495n 1.8v 2009.505n 0.0v 2019.495n 0.0v 2019.505n 0.0v 2029.495n 0.0v 2029.505n 0.0v 2039.495n 0.0v 2039.505n 0.0v 2049.495n 0.0v 2049.505n 0.0v )
* (time, data): [(0, 0), (10, 0), (20, 0), (30, 0), (40, 1), (50, 1), (60, 1), (70, 1), (80, 1), (90, 1), (100, 0), (110, 0), (120, 0), (130, 1), (140, 0), (150, 0), (160, 1), (170, 1), (180, 1), (190, 1), (200, 1), (210, 1), (220, 1), (230, 1), (240, 0), (250, 0), (260, 1), (270, 1), (280, 1), (290, 0), (300, 0), (310, 0), (320, 0), (330, 0), (340, 1), (350, 1), (360, 1), (370, 1), (380, 0), (390, 0), (400, 1), (410, 1), (420, 1), (430, 0), (440, 0), (450, 0), (460, 0), (470, 1), (480, 1), (490, 1), (500, 1), (510, 1), (520, 1), (530, 0), (540, 0), (550, 0), (560, 0), (570, 0), (580, 1), (590, 1), (600, 0), (610, 0), (620, 0), (630, 0), (640, 0), (650, 0), (660, 0), (670, 0), (680, 0), (690, 1), (700, 1), (710, 1), (720, 1), (730, 1), (740, 1), (750, 1), (760, 1), (770, 1), (780, 1), (790, 0), (800, 0), (810, 0), (820, 1), (830, 0), (840, 0), (850, 0), (860, 1), (870, 1), (880, 1), (890, 1), (900, 1), (910, 0), (920, 0), (930, 0), (940, 1), (950, 1), (960, 1), (970, 1), (980, 1), (990, 1), (1000, 1), (1010, 1), (1020, 1), (1030, 1), (1040, 0), (1050, 0), (1060, 1), (1070, 1), (1080, 0), (1090, 0), (1100, 0), (1110, 1), (1120, 1), (1130, 1), (1140, 1), (1150, 1), (1160, 1), (1170, 1), (1180, 0), (1190, 0), (1200, 0), (1210, 0), (1220, 0), (1230, 0), (1240, 0), (1250, 0), (1260, 0), (1270, 0), (1280, 0), (1290, 1), (1300, 1), (1310, 0), (1320, 0), (1330, 0), (1340, 0), (1350, 0), (1360, 0), (1370, 0), (1380, 0), (1390, 0), (1400, 0), (1410, 1), (1420, 0), (1430, 1), (1440, 1), (1450, 1), (1460, 1), (1470, 1), (1480, 1), (1490, 1), (1500, 1), (1510, 1), (1520, 1), (1530, 1), (1540, 1), (1550, 1), (1560, 0), (1570, 0), (1580, 0), (1590, 0), (1600, 0), (1610, 0), (1620, 0), (1630, 0), (1640, 0), (1650, 0), (1660, 0), (1670, 0), (1680, 1), (1690, 1), (1700, 0), (1710, 0), (1720, 0), (1730, 1), (1740, 0), (1750, 0), (1760, 0), (1770, 0), (1780, 0), (1790, 0), (1800, 1), (1810, 1), (1820, 0), (1830, 0), (1840, 1), (1850, 1), (1860, 1), (1870, 0), (1880, 0), (1890, 0), (1900, 0), (1910, 0), (1920, 0), (1930, 0), (1940, 0), (1950, 0), (1960, 1), (1970, 1), (1980, 1), (1990, 1), (2000, 1), (2010, 0), (2020, 0), (2030, 0), (2040, 0), (2050, 0)]
Va1_5  a1_5  0 PWL (0n 0.0v 9.495n 0.0v 9.505n 0.0v 19.495n 0.0v 19.505n 0.0v 29.495n 0.0v 29.505n 0.0v 39.495n 0.0v 39.505n 1.8v 49.495n 1.8v 49.505n 1.8v 59.495n 1.8v 59.505n 1.8v 69.495n 1.8v 69.505n 1.8v 79.495n 1.8v 79.505n 1.8v 89.495n 1.8v 89.505n 1.8v 99.495n 1.8v 99.505n 0.0v 109.495n 0.0v 109.505n 0.0v 119.495n 0.0v 119.505n 0.0v 129.495n 0.0v 129.505n 1.8v 139.495n 1.8v 139.505n 0.0v 149.495n 0.0v 149.505n 0.0v 159.495n 0.0v 159.505n 1.8v 169.495n 1.8v 169.505n 1.8v 179.495n 1.8v 179.505n 1.8v 189.495n 1.8v 189.505n 1.8v 199.495n 1.8v 199.505n 1.8v 209.495n 1.8v 209.505n 1.8v 219.495n 1.8v 219.505n 1.8v 229.495n 1.8v 229.505n 1.8v 239.495n 1.8v 239.505n 0.0v 249.495n 0.0v 249.505n 0.0v 259.495n 0.0v 259.505n 1.8v 269.495n 1.8v 269.505n 1.8v 279.495n 1.8v 279.505n 1.8v 289.495n 1.8v 289.505n 0.0v 299.495n 0.0v 299.505n 0.0v 309.495n 0.0v 309.505n 0.0v 319.495n 0.0v 319.505n 0.0v 329.495n 0.0v 329.505n 0.0v 339.495n 0.0v 339.505n 1.8v 349.495n 1.8v 349.505n 1.8v 359.495n 1.8v 359.505n 1.8v 369.495n 1.8v 369.505n 1.8v 379.495n 1.8v 379.505n 0.0v 389.495n 0.0v 389.505n 0.0v 399.495n 0.0v 399.505n 1.8v 409.495n 1.8v 409.505n 1.8v 419.495n 1.8v 419.505n 1.8v 429.495n 1.8v 429.505n 0.0v 439.495n 0.0v 439.505n 0.0v 449.495n 0.0v 449.505n 0.0v 459.495n 0.0v 459.505n 0.0v 469.495n 0.0v 469.505n 1.8v 479.495n 1.8v 479.505n 1.8v 489.495n 1.8v 489.505n 1.8v 499.495n 1.8v 499.505n 1.8v 509.495n 1.8v 509.505n 1.8v 519.495n 1.8v 519.505n 1.8v 529.495n 1.8v 529.505n 0.0v 539.495n 0.0v 539.505n 0.0v 549.495n 0.0v 549.505n 0.0v 559.495n 0.0v 559.505n 0.0v 569.495n 0.0v 569.505n 0.0v 579.495n 0.0v 579.505n 1.8v 589.495n 1.8v 589.505n 1.8v 599.495n 1.8v 599.505n 0.0v 609.495n 0.0v 609.505n 0.0v 619.495n 0.0v 619.505n 0.0v 629.495n 0.0v 629.505n 0.0v 639.495n 0.0v 639.505n 0.0v 649.495n 0.0v 649.505n 0.0v 659.495n 0.0v 659.505n 0.0v 669.495n 0.0v 669.505n 0.0v 679.495n 0.0v 679.505n 0.0v 689.495n 0.0v 689.505n 1.8v 699.495n 1.8v 699.505n 1.8v 709.495n 1.8v 709.505n 1.8v 719.495n 1.8v 719.505n 1.8v 729.495n 1.8v 729.505n 1.8v 739.495n 1.8v 739.505n 1.8v 749.495n 1.8v 749.505n 1.8v 759.495n 1.8v 759.505n 1.8v 769.495n 1.8v 769.505n 1.8v 779.495n 1.8v 779.505n 1.8v 789.495n 1.8v 789.505n 0.0v 799.495n 0.0v 799.505n 0.0v 809.495n 0.0v 809.505n 0.0v 819.495n 0.0v 819.505n 1.8v 829.495n 1.8v 829.505n 0.0v 839.495n 0.0v 839.505n 0.0v 849.495n 0.0v 849.505n 0.0v 859.495n 0.0v 859.505n 1.8v 869.495n 1.8v 869.505n 1.8v 879.495n 1.8v 879.505n 1.8v 889.495n 1.8v 889.505n 1.8v 899.495n 1.8v 899.505n 1.8v 909.495n 1.8v 909.505n 0.0v 919.495n 0.0v 919.505n 0.0v 929.495n 0.0v 929.505n 0.0v 939.495n 0.0v 939.505n 1.8v 949.495n 1.8v 949.505n 1.8v 959.495n 1.8v 959.505n 1.8v 969.495n 1.8v 969.505n 1.8v 979.495n 1.8v 979.505n 1.8v 989.495n 1.8v 989.505n 1.8v 999.495n 1.8v 999.505n 1.8v 1009.495n 1.8v 1009.505n 1.8v 1019.495n 1.8v 1019.505n 1.8v 1029.495n 1.8v 1029.505n 1.8v 1039.495n 1.8v 1039.505n 0.0v 1049.495n 0.0v 1049.505n 0.0v 1059.495n 0.0v 1059.505n 1.8v 1069.495n 1.8v 1069.505n 1.8v 1079.495n 1.8v 1079.505n 0.0v 1089.495n 0.0v 1089.505n 0.0v 1099.495n 0.0v 1099.505n 0.0v 1109.495n 0.0v 1109.505n 1.8v 1119.495n 1.8v 1119.505n 1.8v 1129.495n 1.8v 1129.505n 1.8v 1139.495n 1.8v 1139.505n 1.8v 1149.495n 1.8v 1149.505n 1.8v 1159.495n 1.8v 1159.505n 1.8v 1169.495n 1.8v 1169.505n 1.8v 1179.495n 1.8v 1179.505n 0.0v 1189.495n 0.0v 1189.505n 0.0v 1199.495n 0.0v 1199.505n 0.0v 1209.495n 0.0v 1209.505n 0.0v 1219.495n 0.0v 1219.505n 0.0v 1229.495n 0.0v 1229.505n 0.0v 1239.495n 0.0v 1239.505n 0.0v 1249.495n 0.0v 1249.505n 0.0v 1259.495n 0.0v 1259.505n 0.0v 1269.495n 0.0v 1269.505n 0.0v 1279.495n 0.0v 1279.505n 0.0v 1289.495n 0.0v 1289.505n 1.8v 1299.495n 1.8v 1299.505n 1.8v 1309.495n 1.8v 1309.505n 0.0v 1319.495n 0.0v 1319.505n 0.0v 1329.495n 0.0v 1329.505n 0.0v 1339.495n 0.0v 1339.505n 0.0v 1349.495n 0.0v 1349.505n 0.0v 1359.495n 0.0v 1359.505n 0.0v 1369.495n 0.0v 1369.505n 0.0v 1379.495n 0.0v 1379.505n 0.0v 1389.495n 0.0v 1389.505n 0.0v 1399.495n 0.0v 1399.505n 0.0v 1409.495n 0.0v 1409.505n 1.8v 1419.495n 1.8v 1419.505n 0.0v 1429.495n 0.0v 1429.505n 1.8v 1439.495n 1.8v 1439.505n 1.8v 1449.495n 1.8v 1449.505n 1.8v 1459.495n 1.8v 1459.505n 1.8v 1469.495n 1.8v 1469.505n 1.8v 1479.495n 1.8v 1479.505n 1.8v 1489.495n 1.8v 1489.505n 1.8v 1499.495n 1.8v 1499.505n 1.8v 1509.495n 1.8v 1509.505n 1.8v 1519.495n 1.8v 1519.505n 1.8v 1529.495n 1.8v 1529.505n 1.8v 1539.495n 1.8v 1539.505n 1.8v 1549.495n 1.8v 1549.505n 1.8v 1559.495n 1.8v 1559.505n 0.0v 1569.495n 0.0v 1569.505n 0.0v 1579.495n 0.0v 1579.505n 0.0v 1589.495n 0.0v 1589.505n 0.0v 1599.495n 0.0v 1599.505n 0.0v 1609.495n 0.0v 1609.505n 0.0v 1619.495n 0.0v 1619.505n 0.0v 1629.495n 0.0v 1629.505n 0.0v 1639.495n 0.0v 1639.505n 0.0v 1649.495n 0.0v 1649.505n 0.0v 1659.495n 0.0v 1659.505n 0.0v 1669.495n 0.0v 1669.505n 0.0v 1679.495n 0.0v 1679.505n 1.8v 1689.495n 1.8v 1689.505n 1.8v 1699.495n 1.8v 1699.505n 0.0v 1709.495n 0.0v 1709.505n 0.0v 1719.495n 0.0v 1719.505n 0.0v 1729.495n 0.0v 1729.505n 1.8v 1739.495n 1.8v 1739.505n 0.0v 1749.495n 0.0v 1749.505n 0.0v 1759.495n 0.0v 1759.505n 0.0v 1769.495n 0.0v 1769.505n 0.0v 1779.495n 0.0v 1779.505n 0.0v 1789.495n 0.0v 1789.505n 0.0v 1799.495n 0.0v 1799.505n 1.8v 1809.495n 1.8v 1809.505n 1.8v 1819.495n 1.8v 1819.505n 0.0v 1829.495n 0.0v 1829.505n 0.0v 1839.495n 0.0v 1839.505n 1.8v 1849.495n 1.8v 1849.505n 1.8v 1859.495n 1.8v 1859.505n 1.8v 1869.495n 1.8v 1869.505n 0.0v 1879.495n 0.0v 1879.505n 0.0v 1889.495n 0.0v 1889.505n 0.0v 1899.495n 0.0v 1899.505n 0.0v 1909.495n 0.0v 1909.505n 0.0v 1919.495n 0.0v 1919.505n 0.0v 1929.495n 0.0v 1929.505n 0.0v 1939.495n 0.0v 1939.505n 0.0v 1949.495n 0.0v 1949.505n 0.0v 1959.495n 0.0v 1959.505n 1.8v 1969.495n 1.8v 1969.505n 1.8v 1979.495n 1.8v 1979.505n 1.8v 1989.495n 1.8v 1989.505n 1.8v 1999.495n 1.8v 1999.505n 1.8v 2009.495n 1.8v 2009.505n 0.0v 2019.495n 0.0v 2019.505n 0.0v 2029.495n 0.0v 2029.505n 0.0v 2039.495n 0.0v 2039.505n 0.0v 2049.495n 0.0v 2049.505n 0.0v )
* (time, data): [(0, 0), (10, 0), (20, 0), (30, 0), (40, 1), (50, 1), (60, 1), (70, 1), (80, 1), (90, 1), (100, 0), (110, 0), (120, 0), (130, 1), (140, 0), (150, 0), (160, 1), (170, 1), (180, 1), (190, 1), (200, 1), (210, 1), (220, 1), (230, 1), (240, 0), (250, 0), (260, 1), (270, 1), (280, 1), (290, 0), (300, 0), (310, 0), (320, 0), (330, 0), (340, 1), (350, 1), (360, 1), (370, 1), (380, 0), (390, 0), (400, 1), (410, 1), (420, 1), (430, 0), (440, 0), (450, 0), (460, 0), (470, 1), (480, 1), (490, 1), (500, 1), (510, 1), (520, 1), (530, 0), (540, 0), (550, 0), (560, 0), (570, 0), (580, 1), (590, 1), (600, 0), (610, 0), (620, 0), (630, 0), (640, 0), (650, 0), (660, 0), (670, 0), (680, 0), (690, 1), (700, 1), (710, 1), (720, 1), (730, 1), (740, 1), (750, 1), (760, 1), (770, 1), (780, 1), (790, 0), (800, 0), (810, 0), (820, 1), (830, 0), (840, 0), (850, 0), (860, 1), (870, 1), (880, 1), (890, 1), (900, 1), (910, 0), (920, 0), (930, 0), (940, 1), (950, 1), (960, 1), (970, 1), (980, 1), (990, 1), (1000, 1), (1010, 1), (1020, 1), (1030, 1), (1040, 0), (1050, 0), (1060, 1), (1070, 1), (1080, 0), (1090, 0), (1100, 0), (1110, 1), (1120, 1), (1130, 1), (1140, 1), (1150, 1), (1160, 1), (1170, 1), (1180, 0), (1190, 0), (1200, 0), (1210, 0), (1220, 0), (1230, 0), (1240, 0), (1250, 0), (1260, 0), (1270, 0), (1280, 0), (1290, 1), (1300, 1), (1310, 0), (1320, 0), (1330, 0), (1340, 0), (1350, 0), (1360, 0), (1370, 0), (1380, 0), (1390, 0), (1400, 0), (1410, 1), (1420, 0), (1430, 1), (1440, 1), (1450, 1), (1460, 1), (1470, 1), (1480, 1), (1490, 1), (1500, 1), (1510, 1), (1520, 1), (1530, 1), (1540, 1), (1550, 1), (1560, 0), (1570, 0), (1580, 0), (1590, 0), (1600, 0), (1610, 0), (1620, 0), (1630, 0), (1640, 0), (1650, 0), (1660, 0), (1670, 0), (1680, 1), (1690, 1), (1700, 0), (1710, 0), (1720, 0), (1730, 1), (1740, 0), (1750, 0), (1760, 0), (1770, 0), (1780, 0), (1790, 0), (1800, 1), (1810, 1), (1820, 0), (1830, 0), (1840, 1), (1850, 1), (1860, 1), (1870, 0), (1880, 0), (1890, 0), (1900, 0), (1910, 0), (1920, 0), (1930, 0), (1940, 0), (1950, 0), (1960, 1), (1970, 1), (1980, 1), (1990, 1), (2000, 1), (2010, 0), (2020, 0), (2030, 0), (2040, 0), (2050, 0)]
Va1_6  a1_6  0 PWL (0n 0.0v 9.495n 0.0v 9.505n 0.0v 19.495n 0.0v 19.505n 0.0v 29.495n 0.0v 29.505n 0.0v 39.495n 0.0v 39.505n 1.8v 49.495n 1.8v 49.505n 1.8v 59.495n 1.8v 59.505n 1.8v 69.495n 1.8v 69.505n 1.8v 79.495n 1.8v 79.505n 1.8v 89.495n 1.8v 89.505n 1.8v 99.495n 1.8v 99.505n 0.0v 109.495n 0.0v 109.505n 0.0v 119.495n 0.0v 119.505n 0.0v 129.495n 0.0v 129.505n 1.8v 139.495n 1.8v 139.505n 0.0v 149.495n 0.0v 149.505n 0.0v 159.495n 0.0v 159.505n 1.8v 169.495n 1.8v 169.505n 1.8v 179.495n 1.8v 179.505n 1.8v 189.495n 1.8v 189.505n 1.8v 199.495n 1.8v 199.505n 1.8v 209.495n 1.8v 209.505n 1.8v 219.495n 1.8v 219.505n 1.8v 229.495n 1.8v 229.505n 1.8v 239.495n 1.8v 239.505n 0.0v 249.495n 0.0v 249.505n 0.0v 259.495n 0.0v 259.505n 1.8v 269.495n 1.8v 269.505n 1.8v 279.495n 1.8v 279.505n 1.8v 289.495n 1.8v 289.505n 0.0v 299.495n 0.0v 299.505n 0.0v 309.495n 0.0v 309.505n 0.0v 319.495n 0.0v 319.505n 0.0v 329.495n 0.0v 329.505n 0.0v 339.495n 0.0v 339.505n 1.8v 349.495n 1.8v 349.505n 1.8v 359.495n 1.8v 359.505n 1.8v 369.495n 1.8v 369.505n 1.8v 379.495n 1.8v 379.505n 0.0v 389.495n 0.0v 389.505n 0.0v 399.495n 0.0v 399.505n 1.8v 409.495n 1.8v 409.505n 1.8v 419.495n 1.8v 419.505n 1.8v 429.495n 1.8v 429.505n 0.0v 439.495n 0.0v 439.505n 0.0v 449.495n 0.0v 449.505n 0.0v 459.495n 0.0v 459.505n 0.0v 469.495n 0.0v 469.505n 1.8v 479.495n 1.8v 479.505n 1.8v 489.495n 1.8v 489.505n 1.8v 499.495n 1.8v 499.505n 1.8v 509.495n 1.8v 509.505n 1.8v 519.495n 1.8v 519.505n 1.8v 529.495n 1.8v 529.505n 0.0v 539.495n 0.0v 539.505n 0.0v 549.495n 0.0v 549.505n 0.0v 559.495n 0.0v 559.505n 0.0v 569.495n 0.0v 569.505n 0.0v 579.495n 0.0v 579.505n 1.8v 589.495n 1.8v 589.505n 1.8v 599.495n 1.8v 599.505n 0.0v 609.495n 0.0v 609.505n 0.0v 619.495n 0.0v 619.505n 0.0v 629.495n 0.0v 629.505n 0.0v 639.495n 0.0v 639.505n 0.0v 649.495n 0.0v 649.505n 0.0v 659.495n 0.0v 659.505n 0.0v 669.495n 0.0v 669.505n 0.0v 679.495n 0.0v 679.505n 0.0v 689.495n 0.0v 689.505n 1.8v 699.495n 1.8v 699.505n 1.8v 709.495n 1.8v 709.505n 1.8v 719.495n 1.8v 719.505n 1.8v 729.495n 1.8v 729.505n 1.8v 739.495n 1.8v 739.505n 1.8v 749.495n 1.8v 749.505n 1.8v 759.495n 1.8v 759.505n 1.8v 769.495n 1.8v 769.505n 1.8v 779.495n 1.8v 779.505n 1.8v 789.495n 1.8v 789.505n 0.0v 799.495n 0.0v 799.505n 0.0v 809.495n 0.0v 809.505n 0.0v 819.495n 0.0v 819.505n 1.8v 829.495n 1.8v 829.505n 0.0v 839.495n 0.0v 839.505n 0.0v 849.495n 0.0v 849.505n 0.0v 859.495n 0.0v 859.505n 1.8v 869.495n 1.8v 869.505n 1.8v 879.495n 1.8v 879.505n 1.8v 889.495n 1.8v 889.505n 1.8v 899.495n 1.8v 899.505n 1.8v 909.495n 1.8v 909.505n 0.0v 919.495n 0.0v 919.505n 0.0v 929.495n 0.0v 929.505n 0.0v 939.495n 0.0v 939.505n 1.8v 949.495n 1.8v 949.505n 1.8v 959.495n 1.8v 959.505n 1.8v 969.495n 1.8v 969.505n 1.8v 979.495n 1.8v 979.505n 1.8v 989.495n 1.8v 989.505n 1.8v 999.495n 1.8v 999.505n 1.8v 1009.495n 1.8v 1009.505n 1.8v 1019.495n 1.8v 1019.505n 1.8v 1029.495n 1.8v 1029.505n 1.8v 1039.495n 1.8v 1039.505n 0.0v 1049.495n 0.0v 1049.505n 0.0v 1059.495n 0.0v 1059.505n 1.8v 1069.495n 1.8v 1069.505n 1.8v 1079.495n 1.8v 1079.505n 0.0v 1089.495n 0.0v 1089.505n 0.0v 1099.495n 0.0v 1099.505n 0.0v 1109.495n 0.0v 1109.505n 1.8v 1119.495n 1.8v 1119.505n 1.8v 1129.495n 1.8v 1129.505n 1.8v 1139.495n 1.8v 1139.505n 1.8v 1149.495n 1.8v 1149.505n 1.8v 1159.495n 1.8v 1159.505n 1.8v 1169.495n 1.8v 1169.505n 1.8v 1179.495n 1.8v 1179.505n 0.0v 1189.495n 0.0v 1189.505n 0.0v 1199.495n 0.0v 1199.505n 0.0v 1209.495n 0.0v 1209.505n 0.0v 1219.495n 0.0v 1219.505n 0.0v 1229.495n 0.0v 1229.505n 0.0v 1239.495n 0.0v 1239.505n 0.0v 1249.495n 0.0v 1249.505n 0.0v 1259.495n 0.0v 1259.505n 0.0v 1269.495n 0.0v 1269.505n 0.0v 1279.495n 0.0v 1279.505n 0.0v 1289.495n 0.0v 1289.505n 1.8v 1299.495n 1.8v 1299.505n 1.8v 1309.495n 1.8v 1309.505n 0.0v 1319.495n 0.0v 1319.505n 0.0v 1329.495n 0.0v 1329.505n 0.0v 1339.495n 0.0v 1339.505n 0.0v 1349.495n 0.0v 1349.505n 0.0v 1359.495n 0.0v 1359.505n 0.0v 1369.495n 0.0v 1369.505n 0.0v 1379.495n 0.0v 1379.505n 0.0v 1389.495n 0.0v 1389.505n 0.0v 1399.495n 0.0v 1399.505n 0.0v 1409.495n 0.0v 1409.505n 1.8v 1419.495n 1.8v 1419.505n 0.0v 1429.495n 0.0v 1429.505n 1.8v 1439.495n 1.8v 1439.505n 1.8v 1449.495n 1.8v 1449.505n 1.8v 1459.495n 1.8v 1459.505n 1.8v 1469.495n 1.8v 1469.505n 1.8v 1479.495n 1.8v 1479.505n 1.8v 1489.495n 1.8v 1489.505n 1.8v 1499.495n 1.8v 1499.505n 1.8v 1509.495n 1.8v 1509.505n 1.8v 1519.495n 1.8v 1519.505n 1.8v 1529.495n 1.8v 1529.505n 1.8v 1539.495n 1.8v 1539.505n 1.8v 1549.495n 1.8v 1549.505n 1.8v 1559.495n 1.8v 1559.505n 0.0v 1569.495n 0.0v 1569.505n 0.0v 1579.495n 0.0v 1579.505n 0.0v 1589.495n 0.0v 1589.505n 0.0v 1599.495n 0.0v 1599.505n 0.0v 1609.495n 0.0v 1609.505n 0.0v 1619.495n 0.0v 1619.505n 0.0v 1629.495n 0.0v 1629.505n 0.0v 1639.495n 0.0v 1639.505n 0.0v 1649.495n 0.0v 1649.505n 0.0v 1659.495n 0.0v 1659.505n 0.0v 1669.495n 0.0v 1669.505n 0.0v 1679.495n 0.0v 1679.505n 1.8v 1689.495n 1.8v 1689.505n 1.8v 1699.495n 1.8v 1699.505n 0.0v 1709.495n 0.0v 1709.505n 0.0v 1719.495n 0.0v 1719.505n 0.0v 1729.495n 0.0v 1729.505n 1.8v 1739.495n 1.8v 1739.505n 0.0v 1749.495n 0.0v 1749.505n 0.0v 1759.495n 0.0v 1759.505n 0.0v 1769.495n 0.0v 1769.505n 0.0v 1779.495n 0.0v 1779.505n 0.0v 1789.495n 0.0v 1789.505n 0.0v 1799.495n 0.0v 1799.505n 1.8v 1809.495n 1.8v 1809.505n 1.8v 1819.495n 1.8v 1819.505n 0.0v 1829.495n 0.0v 1829.505n 0.0v 1839.495n 0.0v 1839.505n 1.8v 1849.495n 1.8v 1849.505n 1.8v 1859.495n 1.8v 1859.505n 1.8v 1869.495n 1.8v 1869.505n 0.0v 1879.495n 0.0v 1879.505n 0.0v 1889.495n 0.0v 1889.505n 0.0v 1899.495n 0.0v 1899.505n 0.0v 1909.495n 0.0v 1909.505n 0.0v 1919.495n 0.0v 1919.505n 0.0v 1929.495n 0.0v 1929.505n 0.0v 1939.495n 0.0v 1939.505n 0.0v 1949.495n 0.0v 1949.505n 0.0v 1959.495n 0.0v 1959.505n 1.8v 1969.495n 1.8v 1969.505n 1.8v 1979.495n 1.8v 1979.505n 1.8v 1989.495n 1.8v 1989.505n 1.8v 1999.495n 1.8v 1999.505n 1.8v 2009.495n 1.8v 2009.505n 0.0v 2019.495n 0.0v 2019.505n 0.0v 2029.495n 0.0v 2029.505n 0.0v 2039.495n 0.0v 2039.505n 0.0v 2049.495n 0.0v 2049.505n 0.0v )
* (time, data): [(0, 0), (10, 0), (20, 0), (30, 0), (40, 1), (50, 1), (60, 1), (70, 1), (80, 1), (90, 1), (100, 0), (110, 0), (120, 0), (130, 1), (140, 0), (150, 0), (160, 1), (170, 1), (180, 1), (190, 1), (200, 1), (210, 1), (220, 1), (230, 1), (240, 0), (250, 0), (260, 1), (270, 1), (280, 1), (290, 0), (300, 0), (310, 0), (320, 0), (330, 0), (340, 1), (350, 1), (360, 1), (370, 1), (380, 0), (390, 0), (400, 1), (410, 1), (420, 1), (430, 0), (440, 0), (450, 0), (460, 0), (470, 1), (480, 1), (490, 1), (500, 1), (510, 1), (520, 1), (530, 0), (540, 0), (550, 0), (560, 0), (570, 0), (580, 1), (590, 1), (600, 0), (610, 0), (620, 0), (630, 0), (640, 0), (650, 0), (660, 0), (670, 0), (680, 0), (690, 1), (700, 1), (710, 1), (720, 1), (730, 1), (740, 1), (750, 1), (760, 1), (770, 1), (780, 1), (790, 0), (800, 0), (810, 0), (820, 1), (830, 0), (840, 0), (850, 0), (860, 1), (870, 1), (880, 1), (890, 1), (900, 1), (910, 0), (920, 0), (930, 0), (940, 1), (950, 1), (960, 1), (970, 1), (980, 1), (990, 1), (1000, 1), (1010, 1), (1020, 1), (1030, 1), (1040, 0), (1050, 0), (1060, 1), (1070, 1), (1080, 0), (1090, 0), (1100, 0), (1110, 1), (1120, 1), (1130, 1), (1140, 1), (1150, 1), (1160, 1), (1170, 1), (1180, 0), (1190, 0), (1200, 0), (1210, 0), (1220, 0), (1230, 0), (1240, 0), (1250, 0), (1260, 0), (1270, 0), (1280, 0), (1290, 1), (1300, 1), (1310, 0), (1320, 0), (1330, 0), (1340, 0), (1350, 0), (1360, 0), (1370, 0), (1380, 0), (1390, 0), (1400, 0), (1410, 1), (1420, 0), (1430, 1), (1440, 1), (1450, 1), (1460, 1), (1470, 1), (1480, 1), (1490, 1), (1500, 1), (1510, 1), (1520, 1), (1530, 1), (1540, 1), (1550, 1), (1560, 0), (1570, 0), (1580, 0), (1590, 0), (1600, 0), (1610, 0), (1620, 0), (1630, 0), (1640, 0), (1650, 0), (1660, 0), (1670, 0), (1680, 1), (1690, 1), (1700, 0), (1710, 0), (1720, 0), (1730, 1), (1740, 0), (1750, 0), (1760, 0), (1770, 0), (1780, 0), (1790, 0), (1800, 1), (1810, 1), (1820, 0), (1830, 0), (1840, 1), (1850, 1), (1860, 1), (1870, 0), (1880, 0), (1890, 0), (1900, 0), (1910, 0), (1920, 0), (1930, 0), (1940, 0), (1950, 0), (1960, 1), (1970, 1), (1980, 1), (1990, 1), (2000, 1), (2010, 0), (2020, 0), (2030, 0), (2040, 0), (2050, 0)]
Va1_7  a1_7  0 PWL (0n 0.0v 9.495n 0.0v 9.505n 0.0v 19.495n 0.0v 19.505n 0.0v 29.495n 0.0v 29.505n 0.0v 39.495n 0.0v 39.505n 1.8v 49.495n 1.8v 49.505n 1.8v 59.495n 1.8v 59.505n 1.8v 69.495n 1.8v 69.505n 1.8v 79.495n 1.8v 79.505n 1.8v 89.495n 1.8v 89.505n 1.8v 99.495n 1.8v 99.505n 0.0v 109.495n 0.0v 109.505n 0.0v 119.495n 0.0v 119.505n 0.0v 129.495n 0.0v 129.505n 1.8v 139.495n 1.8v 139.505n 0.0v 149.495n 0.0v 149.505n 0.0v 159.495n 0.0v 159.505n 1.8v 169.495n 1.8v 169.505n 1.8v 179.495n 1.8v 179.505n 1.8v 189.495n 1.8v 189.505n 1.8v 199.495n 1.8v 199.505n 1.8v 209.495n 1.8v 209.505n 1.8v 219.495n 1.8v 219.505n 1.8v 229.495n 1.8v 229.505n 1.8v 239.495n 1.8v 239.505n 0.0v 249.495n 0.0v 249.505n 0.0v 259.495n 0.0v 259.505n 1.8v 269.495n 1.8v 269.505n 1.8v 279.495n 1.8v 279.505n 1.8v 289.495n 1.8v 289.505n 0.0v 299.495n 0.0v 299.505n 0.0v 309.495n 0.0v 309.505n 0.0v 319.495n 0.0v 319.505n 0.0v 329.495n 0.0v 329.505n 0.0v 339.495n 0.0v 339.505n 1.8v 349.495n 1.8v 349.505n 1.8v 359.495n 1.8v 359.505n 1.8v 369.495n 1.8v 369.505n 1.8v 379.495n 1.8v 379.505n 0.0v 389.495n 0.0v 389.505n 0.0v 399.495n 0.0v 399.505n 1.8v 409.495n 1.8v 409.505n 1.8v 419.495n 1.8v 419.505n 1.8v 429.495n 1.8v 429.505n 0.0v 439.495n 0.0v 439.505n 0.0v 449.495n 0.0v 449.505n 0.0v 459.495n 0.0v 459.505n 0.0v 469.495n 0.0v 469.505n 1.8v 479.495n 1.8v 479.505n 1.8v 489.495n 1.8v 489.505n 1.8v 499.495n 1.8v 499.505n 1.8v 509.495n 1.8v 509.505n 1.8v 519.495n 1.8v 519.505n 1.8v 529.495n 1.8v 529.505n 0.0v 539.495n 0.0v 539.505n 0.0v 549.495n 0.0v 549.505n 0.0v 559.495n 0.0v 559.505n 0.0v 569.495n 0.0v 569.505n 0.0v 579.495n 0.0v 579.505n 1.8v 589.495n 1.8v 589.505n 1.8v 599.495n 1.8v 599.505n 0.0v 609.495n 0.0v 609.505n 0.0v 619.495n 0.0v 619.505n 0.0v 629.495n 0.0v 629.505n 0.0v 639.495n 0.0v 639.505n 0.0v 649.495n 0.0v 649.505n 0.0v 659.495n 0.0v 659.505n 0.0v 669.495n 0.0v 669.505n 0.0v 679.495n 0.0v 679.505n 0.0v 689.495n 0.0v 689.505n 1.8v 699.495n 1.8v 699.505n 1.8v 709.495n 1.8v 709.505n 1.8v 719.495n 1.8v 719.505n 1.8v 729.495n 1.8v 729.505n 1.8v 739.495n 1.8v 739.505n 1.8v 749.495n 1.8v 749.505n 1.8v 759.495n 1.8v 759.505n 1.8v 769.495n 1.8v 769.505n 1.8v 779.495n 1.8v 779.505n 1.8v 789.495n 1.8v 789.505n 0.0v 799.495n 0.0v 799.505n 0.0v 809.495n 0.0v 809.505n 0.0v 819.495n 0.0v 819.505n 1.8v 829.495n 1.8v 829.505n 0.0v 839.495n 0.0v 839.505n 0.0v 849.495n 0.0v 849.505n 0.0v 859.495n 0.0v 859.505n 1.8v 869.495n 1.8v 869.505n 1.8v 879.495n 1.8v 879.505n 1.8v 889.495n 1.8v 889.505n 1.8v 899.495n 1.8v 899.505n 1.8v 909.495n 1.8v 909.505n 0.0v 919.495n 0.0v 919.505n 0.0v 929.495n 0.0v 929.505n 0.0v 939.495n 0.0v 939.505n 1.8v 949.495n 1.8v 949.505n 1.8v 959.495n 1.8v 959.505n 1.8v 969.495n 1.8v 969.505n 1.8v 979.495n 1.8v 979.505n 1.8v 989.495n 1.8v 989.505n 1.8v 999.495n 1.8v 999.505n 1.8v 1009.495n 1.8v 1009.505n 1.8v 1019.495n 1.8v 1019.505n 1.8v 1029.495n 1.8v 1029.505n 1.8v 1039.495n 1.8v 1039.505n 0.0v 1049.495n 0.0v 1049.505n 0.0v 1059.495n 0.0v 1059.505n 1.8v 1069.495n 1.8v 1069.505n 1.8v 1079.495n 1.8v 1079.505n 0.0v 1089.495n 0.0v 1089.505n 0.0v 1099.495n 0.0v 1099.505n 0.0v 1109.495n 0.0v 1109.505n 1.8v 1119.495n 1.8v 1119.505n 1.8v 1129.495n 1.8v 1129.505n 1.8v 1139.495n 1.8v 1139.505n 1.8v 1149.495n 1.8v 1149.505n 1.8v 1159.495n 1.8v 1159.505n 1.8v 1169.495n 1.8v 1169.505n 1.8v 1179.495n 1.8v 1179.505n 0.0v 1189.495n 0.0v 1189.505n 0.0v 1199.495n 0.0v 1199.505n 0.0v 1209.495n 0.0v 1209.505n 0.0v 1219.495n 0.0v 1219.505n 0.0v 1229.495n 0.0v 1229.505n 0.0v 1239.495n 0.0v 1239.505n 0.0v 1249.495n 0.0v 1249.505n 0.0v 1259.495n 0.0v 1259.505n 0.0v 1269.495n 0.0v 1269.505n 0.0v 1279.495n 0.0v 1279.505n 0.0v 1289.495n 0.0v 1289.505n 1.8v 1299.495n 1.8v 1299.505n 1.8v 1309.495n 1.8v 1309.505n 0.0v 1319.495n 0.0v 1319.505n 0.0v 1329.495n 0.0v 1329.505n 0.0v 1339.495n 0.0v 1339.505n 0.0v 1349.495n 0.0v 1349.505n 0.0v 1359.495n 0.0v 1359.505n 0.0v 1369.495n 0.0v 1369.505n 0.0v 1379.495n 0.0v 1379.505n 0.0v 1389.495n 0.0v 1389.505n 0.0v 1399.495n 0.0v 1399.505n 0.0v 1409.495n 0.0v 1409.505n 1.8v 1419.495n 1.8v 1419.505n 0.0v 1429.495n 0.0v 1429.505n 1.8v 1439.495n 1.8v 1439.505n 1.8v 1449.495n 1.8v 1449.505n 1.8v 1459.495n 1.8v 1459.505n 1.8v 1469.495n 1.8v 1469.505n 1.8v 1479.495n 1.8v 1479.505n 1.8v 1489.495n 1.8v 1489.505n 1.8v 1499.495n 1.8v 1499.505n 1.8v 1509.495n 1.8v 1509.505n 1.8v 1519.495n 1.8v 1519.505n 1.8v 1529.495n 1.8v 1529.505n 1.8v 1539.495n 1.8v 1539.505n 1.8v 1549.495n 1.8v 1549.505n 1.8v 1559.495n 1.8v 1559.505n 0.0v 1569.495n 0.0v 1569.505n 0.0v 1579.495n 0.0v 1579.505n 0.0v 1589.495n 0.0v 1589.505n 0.0v 1599.495n 0.0v 1599.505n 0.0v 1609.495n 0.0v 1609.505n 0.0v 1619.495n 0.0v 1619.505n 0.0v 1629.495n 0.0v 1629.505n 0.0v 1639.495n 0.0v 1639.505n 0.0v 1649.495n 0.0v 1649.505n 0.0v 1659.495n 0.0v 1659.505n 0.0v 1669.495n 0.0v 1669.505n 0.0v 1679.495n 0.0v 1679.505n 1.8v 1689.495n 1.8v 1689.505n 1.8v 1699.495n 1.8v 1699.505n 0.0v 1709.495n 0.0v 1709.505n 0.0v 1719.495n 0.0v 1719.505n 0.0v 1729.495n 0.0v 1729.505n 1.8v 1739.495n 1.8v 1739.505n 0.0v 1749.495n 0.0v 1749.505n 0.0v 1759.495n 0.0v 1759.505n 0.0v 1769.495n 0.0v 1769.505n 0.0v 1779.495n 0.0v 1779.505n 0.0v 1789.495n 0.0v 1789.505n 0.0v 1799.495n 0.0v 1799.505n 1.8v 1809.495n 1.8v 1809.505n 1.8v 1819.495n 1.8v 1819.505n 0.0v 1829.495n 0.0v 1829.505n 0.0v 1839.495n 0.0v 1839.505n 1.8v 1849.495n 1.8v 1849.505n 1.8v 1859.495n 1.8v 1859.505n 1.8v 1869.495n 1.8v 1869.505n 0.0v 1879.495n 0.0v 1879.505n 0.0v 1889.495n 0.0v 1889.505n 0.0v 1899.495n 0.0v 1899.505n 0.0v 1909.495n 0.0v 1909.505n 0.0v 1919.495n 0.0v 1919.505n 0.0v 1929.495n 0.0v 1929.505n 0.0v 1939.495n 0.0v 1939.505n 0.0v 1949.495n 0.0v 1949.505n 0.0v 1959.495n 0.0v 1959.505n 1.8v 1969.495n 1.8v 1969.505n 1.8v 1979.495n 1.8v 1979.505n 1.8v 1989.495n 1.8v 1989.505n 1.8v 1999.495n 1.8v 1999.505n 1.8v 2009.495n 1.8v 2009.505n 0.0v 2019.495n 0.0v 2019.505n 0.0v 2029.495n 0.0v 2029.505n 0.0v 2039.495n 0.0v 2039.505n 0.0v 2049.495n 0.0v 2049.505n 0.0v )
* (time, data): [(0, 0), (10, 0), (20, 0), (30, 0), (40, 1), (50, 1), (60, 1), (70, 1), (80, 1), (90, 1), (100, 0), (110, 0), (120, 0), (130, 1), (140, 0), (150, 0), (160, 1), (170, 1), (180, 1), (190, 1), (200, 1), (210, 1), (220, 1), (230, 1), (240, 0), (250, 0), (260, 1), (270, 1), (280, 1), (290, 0), (300, 0), (310, 0), (320, 0), (330, 0), (340, 1), (350, 1), (360, 1), (370, 1), (380, 0), (390, 0), (400, 1), (410, 1), (420, 1), (430, 0), (440, 0), (450, 0), (460, 0), (470, 1), (480, 1), (490, 1), (500, 1), (510, 1), (520, 1), (530, 0), (540, 0), (550, 0), (560, 0), (570, 0), (580, 1), (590, 1), (600, 0), (610, 0), (620, 0), (630, 0), (640, 0), (650, 0), (660, 0), (670, 0), (680, 0), (690, 1), (700, 1), (710, 1), (720, 1), (730, 1), (740, 1), (750, 1), (760, 1), (770, 1), (780, 1), (790, 0), (800, 0), (810, 0), (820, 1), (830, 0), (840, 0), (850, 0), (860, 1), (870, 1), (880, 1), (890, 1), (900, 1), (910, 0), (920, 0), (930, 0), (940, 1), (950, 1), (960, 1), (970, 1), (980, 1), (990, 1), (1000, 1), (1010, 1), (1020, 1), (1030, 1), (1040, 0), (1050, 0), (1060, 1), (1070, 1), (1080, 0), (1090, 0), (1100, 0), (1110, 1), (1120, 1), (1130, 1), (1140, 1), (1150, 1), (1160, 1), (1170, 1), (1180, 0), (1190, 0), (1200, 0), (1210, 0), (1220, 0), (1230, 0), (1240, 0), (1250, 0), (1260, 0), (1270, 0), (1280, 0), (1290, 1), (1300, 1), (1310, 0), (1320, 0), (1330, 0), (1340, 0), (1350, 0), (1360, 0), (1370, 0), (1380, 0), (1390, 0), (1400, 0), (1410, 1), (1420, 0), (1430, 1), (1440, 1), (1450, 1), (1460, 1), (1470, 1), (1480, 1), (1490, 1), (1500, 1), (1510, 1), (1520, 1), (1530, 1), (1540, 1), (1550, 1), (1560, 0), (1570, 0), (1580, 0), (1590, 0), (1600, 0), (1610, 0), (1620, 0), (1630, 0), (1640, 0), (1650, 0), (1660, 0), (1670, 0), (1680, 1), (1690, 1), (1700, 0), (1710, 0), (1720, 0), (1730, 1), (1740, 0), (1750, 0), (1760, 0), (1770, 0), (1780, 0), (1790, 0), (1800, 1), (1810, 1), (1820, 0), (1830, 0), (1840, 1), (1850, 1), (1860, 1), (1870, 0), (1880, 0), (1890, 0), (1900, 0), (1910, 0), (1920, 0), (1930, 0), (1940, 0), (1950, 0), (1960, 1), (1970, 1), (1980, 1), (1990, 1), (2000, 1), (2010, 0), (2020, 0), (2030, 0), (2040, 0), (2050, 0)]
Va1_8  a1_8  0 PWL (0n 0.0v 9.495n 0.0v 9.505n 0.0v 19.495n 0.0v 19.505n 0.0v 29.495n 0.0v 29.505n 0.0v 39.495n 0.0v 39.505n 1.8v 49.495n 1.8v 49.505n 1.8v 59.495n 1.8v 59.505n 1.8v 69.495n 1.8v 69.505n 1.8v 79.495n 1.8v 79.505n 1.8v 89.495n 1.8v 89.505n 1.8v 99.495n 1.8v 99.505n 0.0v 109.495n 0.0v 109.505n 0.0v 119.495n 0.0v 119.505n 0.0v 129.495n 0.0v 129.505n 1.8v 139.495n 1.8v 139.505n 0.0v 149.495n 0.0v 149.505n 0.0v 159.495n 0.0v 159.505n 1.8v 169.495n 1.8v 169.505n 1.8v 179.495n 1.8v 179.505n 1.8v 189.495n 1.8v 189.505n 1.8v 199.495n 1.8v 199.505n 1.8v 209.495n 1.8v 209.505n 1.8v 219.495n 1.8v 219.505n 1.8v 229.495n 1.8v 229.505n 1.8v 239.495n 1.8v 239.505n 0.0v 249.495n 0.0v 249.505n 0.0v 259.495n 0.0v 259.505n 1.8v 269.495n 1.8v 269.505n 1.8v 279.495n 1.8v 279.505n 1.8v 289.495n 1.8v 289.505n 0.0v 299.495n 0.0v 299.505n 0.0v 309.495n 0.0v 309.505n 0.0v 319.495n 0.0v 319.505n 0.0v 329.495n 0.0v 329.505n 0.0v 339.495n 0.0v 339.505n 1.8v 349.495n 1.8v 349.505n 1.8v 359.495n 1.8v 359.505n 1.8v 369.495n 1.8v 369.505n 1.8v 379.495n 1.8v 379.505n 0.0v 389.495n 0.0v 389.505n 0.0v 399.495n 0.0v 399.505n 1.8v 409.495n 1.8v 409.505n 1.8v 419.495n 1.8v 419.505n 1.8v 429.495n 1.8v 429.505n 0.0v 439.495n 0.0v 439.505n 0.0v 449.495n 0.0v 449.505n 0.0v 459.495n 0.0v 459.505n 0.0v 469.495n 0.0v 469.505n 1.8v 479.495n 1.8v 479.505n 1.8v 489.495n 1.8v 489.505n 1.8v 499.495n 1.8v 499.505n 1.8v 509.495n 1.8v 509.505n 1.8v 519.495n 1.8v 519.505n 1.8v 529.495n 1.8v 529.505n 0.0v 539.495n 0.0v 539.505n 0.0v 549.495n 0.0v 549.505n 0.0v 559.495n 0.0v 559.505n 0.0v 569.495n 0.0v 569.505n 0.0v 579.495n 0.0v 579.505n 1.8v 589.495n 1.8v 589.505n 1.8v 599.495n 1.8v 599.505n 0.0v 609.495n 0.0v 609.505n 0.0v 619.495n 0.0v 619.505n 0.0v 629.495n 0.0v 629.505n 0.0v 639.495n 0.0v 639.505n 0.0v 649.495n 0.0v 649.505n 0.0v 659.495n 0.0v 659.505n 0.0v 669.495n 0.0v 669.505n 0.0v 679.495n 0.0v 679.505n 0.0v 689.495n 0.0v 689.505n 1.8v 699.495n 1.8v 699.505n 1.8v 709.495n 1.8v 709.505n 1.8v 719.495n 1.8v 719.505n 1.8v 729.495n 1.8v 729.505n 1.8v 739.495n 1.8v 739.505n 1.8v 749.495n 1.8v 749.505n 1.8v 759.495n 1.8v 759.505n 1.8v 769.495n 1.8v 769.505n 1.8v 779.495n 1.8v 779.505n 1.8v 789.495n 1.8v 789.505n 0.0v 799.495n 0.0v 799.505n 0.0v 809.495n 0.0v 809.505n 0.0v 819.495n 0.0v 819.505n 1.8v 829.495n 1.8v 829.505n 0.0v 839.495n 0.0v 839.505n 0.0v 849.495n 0.0v 849.505n 0.0v 859.495n 0.0v 859.505n 1.8v 869.495n 1.8v 869.505n 1.8v 879.495n 1.8v 879.505n 1.8v 889.495n 1.8v 889.505n 1.8v 899.495n 1.8v 899.505n 1.8v 909.495n 1.8v 909.505n 0.0v 919.495n 0.0v 919.505n 0.0v 929.495n 0.0v 929.505n 0.0v 939.495n 0.0v 939.505n 1.8v 949.495n 1.8v 949.505n 1.8v 959.495n 1.8v 959.505n 1.8v 969.495n 1.8v 969.505n 1.8v 979.495n 1.8v 979.505n 1.8v 989.495n 1.8v 989.505n 1.8v 999.495n 1.8v 999.505n 1.8v 1009.495n 1.8v 1009.505n 1.8v 1019.495n 1.8v 1019.505n 1.8v 1029.495n 1.8v 1029.505n 1.8v 1039.495n 1.8v 1039.505n 0.0v 1049.495n 0.0v 1049.505n 0.0v 1059.495n 0.0v 1059.505n 1.8v 1069.495n 1.8v 1069.505n 1.8v 1079.495n 1.8v 1079.505n 0.0v 1089.495n 0.0v 1089.505n 0.0v 1099.495n 0.0v 1099.505n 0.0v 1109.495n 0.0v 1109.505n 1.8v 1119.495n 1.8v 1119.505n 1.8v 1129.495n 1.8v 1129.505n 1.8v 1139.495n 1.8v 1139.505n 1.8v 1149.495n 1.8v 1149.505n 1.8v 1159.495n 1.8v 1159.505n 1.8v 1169.495n 1.8v 1169.505n 1.8v 1179.495n 1.8v 1179.505n 0.0v 1189.495n 0.0v 1189.505n 0.0v 1199.495n 0.0v 1199.505n 0.0v 1209.495n 0.0v 1209.505n 0.0v 1219.495n 0.0v 1219.505n 0.0v 1229.495n 0.0v 1229.505n 0.0v 1239.495n 0.0v 1239.505n 0.0v 1249.495n 0.0v 1249.505n 0.0v 1259.495n 0.0v 1259.505n 0.0v 1269.495n 0.0v 1269.505n 0.0v 1279.495n 0.0v 1279.505n 0.0v 1289.495n 0.0v 1289.505n 1.8v 1299.495n 1.8v 1299.505n 1.8v 1309.495n 1.8v 1309.505n 0.0v 1319.495n 0.0v 1319.505n 0.0v 1329.495n 0.0v 1329.505n 0.0v 1339.495n 0.0v 1339.505n 0.0v 1349.495n 0.0v 1349.505n 0.0v 1359.495n 0.0v 1359.505n 0.0v 1369.495n 0.0v 1369.505n 0.0v 1379.495n 0.0v 1379.505n 0.0v 1389.495n 0.0v 1389.505n 0.0v 1399.495n 0.0v 1399.505n 0.0v 1409.495n 0.0v 1409.505n 1.8v 1419.495n 1.8v 1419.505n 0.0v 1429.495n 0.0v 1429.505n 1.8v 1439.495n 1.8v 1439.505n 1.8v 1449.495n 1.8v 1449.505n 1.8v 1459.495n 1.8v 1459.505n 1.8v 1469.495n 1.8v 1469.505n 1.8v 1479.495n 1.8v 1479.505n 1.8v 1489.495n 1.8v 1489.505n 1.8v 1499.495n 1.8v 1499.505n 1.8v 1509.495n 1.8v 1509.505n 1.8v 1519.495n 1.8v 1519.505n 1.8v 1529.495n 1.8v 1529.505n 1.8v 1539.495n 1.8v 1539.505n 1.8v 1549.495n 1.8v 1549.505n 1.8v 1559.495n 1.8v 1559.505n 0.0v 1569.495n 0.0v 1569.505n 0.0v 1579.495n 0.0v 1579.505n 0.0v 1589.495n 0.0v 1589.505n 0.0v 1599.495n 0.0v 1599.505n 0.0v 1609.495n 0.0v 1609.505n 0.0v 1619.495n 0.0v 1619.505n 0.0v 1629.495n 0.0v 1629.505n 0.0v 1639.495n 0.0v 1639.505n 0.0v 1649.495n 0.0v 1649.505n 0.0v 1659.495n 0.0v 1659.505n 0.0v 1669.495n 0.0v 1669.505n 0.0v 1679.495n 0.0v 1679.505n 1.8v 1689.495n 1.8v 1689.505n 1.8v 1699.495n 1.8v 1699.505n 0.0v 1709.495n 0.0v 1709.505n 0.0v 1719.495n 0.0v 1719.505n 0.0v 1729.495n 0.0v 1729.505n 1.8v 1739.495n 1.8v 1739.505n 0.0v 1749.495n 0.0v 1749.505n 0.0v 1759.495n 0.0v 1759.505n 0.0v 1769.495n 0.0v 1769.505n 0.0v 1779.495n 0.0v 1779.505n 0.0v 1789.495n 0.0v 1789.505n 0.0v 1799.495n 0.0v 1799.505n 1.8v 1809.495n 1.8v 1809.505n 1.8v 1819.495n 1.8v 1819.505n 0.0v 1829.495n 0.0v 1829.505n 0.0v 1839.495n 0.0v 1839.505n 1.8v 1849.495n 1.8v 1849.505n 1.8v 1859.495n 1.8v 1859.505n 1.8v 1869.495n 1.8v 1869.505n 0.0v 1879.495n 0.0v 1879.505n 0.0v 1889.495n 0.0v 1889.505n 0.0v 1899.495n 0.0v 1899.505n 0.0v 1909.495n 0.0v 1909.505n 0.0v 1919.495n 0.0v 1919.505n 0.0v 1929.495n 0.0v 1929.505n 0.0v 1939.495n 0.0v 1939.505n 0.0v 1949.495n 0.0v 1949.505n 0.0v 1959.495n 0.0v 1959.505n 1.8v 1969.495n 1.8v 1969.505n 1.8v 1979.495n 1.8v 1979.505n 1.8v 1989.495n 1.8v 1989.505n 1.8v 1999.495n 1.8v 1999.505n 1.8v 2009.495n 1.8v 2009.505n 0.0v 2019.495n 0.0v 2019.505n 0.0v 2029.495n 0.0v 2029.505n 0.0v 2039.495n 0.0v 2039.505n 0.0v 2049.495n 0.0v 2049.505n 0.0v )
* (time, data): [(0, 0), (10, 0), (20, 0), (30, 0), (40, 1), (50, 1), (60, 1), (70, 1), (80, 1), (90, 1), (100, 0), (110, 0), (120, 0), (130, 1), (140, 0), (150, 0), (160, 1), (170, 1), (180, 1), (190, 1), (200, 1), (210, 1), (220, 1), (230, 1), (240, 0), (250, 0), (260, 1), (270, 1), (280, 1), (290, 0), (300, 0), (310, 0), (320, 0), (330, 0), (340, 1), (350, 1), (360, 1), (370, 1), (380, 0), (390, 0), (400, 1), (410, 1), (420, 1), (430, 0), (440, 0), (450, 0), (460, 0), (470, 1), (480, 1), (490, 1), (500, 1), (510, 1), (520, 1), (530, 0), (540, 0), (550, 0), (560, 0), (570, 0), (580, 1), (590, 1), (600, 0), (610, 0), (620, 0), (630, 0), (640, 0), (650, 0), (660, 0), (670, 0), (680, 0), (690, 1), (700, 1), (710, 1), (720, 1), (730, 1), (740, 1), (750, 1), (760, 1), (770, 1), (780, 1), (790, 0), (800, 0), (810, 0), (820, 1), (830, 0), (840, 0), (850, 0), (860, 1), (870, 1), (880, 1), (890, 1), (900, 1), (910, 0), (920, 0), (930, 0), (940, 1), (950, 1), (960, 1), (970, 1), (980, 1), (990, 1), (1000, 1), (1010, 1), (1020, 1), (1030, 1), (1040, 0), (1050, 0), (1060, 1), (1070, 1), (1080, 0), (1090, 0), (1100, 0), (1110, 1), (1120, 1), (1130, 1), (1140, 1), (1150, 1), (1160, 1), (1170, 1), (1180, 0), (1190, 0), (1200, 0), (1210, 0), (1220, 0), (1230, 0), (1240, 0), (1250, 0), (1260, 0), (1270, 0), (1280, 0), (1290, 1), (1300, 1), (1310, 0), (1320, 0), (1330, 0), (1340, 0), (1350, 0), (1360, 0), (1370, 0), (1380, 0), (1390, 0), (1400, 0), (1410, 1), (1420, 0), (1430, 1), (1440, 1), (1450, 1), (1460, 1), (1470, 1), (1480, 1), (1490, 1), (1500, 1), (1510, 1), (1520, 1), (1530, 1), (1540, 1), (1550, 1), (1560, 0), (1570, 0), (1580, 0), (1590, 0), (1600, 0), (1610, 0), (1620, 0), (1630, 0), (1640, 0), (1650, 0), (1660, 0), (1670, 0), (1680, 1), (1690, 1), (1700, 0), (1710, 0), (1720, 0), (1730, 1), (1740, 0), (1750, 0), (1760, 0), (1770, 0), (1780, 0), (1790, 0), (1800, 1), (1810, 1), (1820, 0), (1830, 0), (1840, 1), (1850, 1), (1860, 1), (1870, 0), (1880, 0), (1890, 0), (1900, 0), (1910, 0), (1920, 0), (1930, 0), (1940, 0), (1950, 0), (1960, 1), (1970, 1), (1980, 1), (1990, 1), (2000, 1), (2010, 0), (2020, 0), (2030, 0), (2040, 0), (2050, 0)]
Va1_9  a1_9  0 PWL (0n 0.0v 9.495n 0.0v 9.505n 0.0v 19.495n 0.0v 19.505n 0.0v 29.495n 0.0v 29.505n 0.0v 39.495n 0.0v 39.505n 1.8v 49.495n 1.8v 49.505n 1.8v 59.495n 1.8v 59.505n 1.8v 69.495n 1.8v 69.505n 1.8v 79.495n 1.8v 79.505n 1.8v 89.495n 1.8v 89.505n 1.8v 99.495n 1.8v 99.505n 0.0v 109.495n 0.0v 109.505n 0.0v 119.495n 0.0v 119.505n 0.0v 129.495n 0.0v 129.505n 1.8v 139.495n 1.8v 139.505n 0.0v 149.495n 0.0v 149.505n 0.0v 159.495n 0.0v 159.505n 1.8v 169.495n 1.8v 169.505n 1.8v 179.495n 1.8v 179.505n 1.8v 189.495n 1.8v 189.505n 1.8v 199.495n 1.8v 199.505n 1.8v 209.495n 1.8v 209.505n 1.8v 219.495n 1.8v 219.505n 1.8v 229.495n 1.8v 229.505n 1.8v 239.495n 1.8v 239.505n 0.0v 249.495n 0.0v 249.505n 0.0v 259.495n 0.0v 259.505n 1.8v 269.495n 1.8v 269.505n 1.8v 279.495n 1.8v 279.505n 1.8v 289.495n 1.8v 289.505n 0.0v 299.495n 0.0v 299.505n 0.0v 309.495n 0.0v 309.505n 0.0v 319.495n 0.0v 319.505n 0.0v 329.495n 0.0v 329.505n 0.0v 339.495n 0.0v 339.505n 1.8v 349.495n 1.8v 349.505n 1.8v 359.495n 1.8v 359.505n 1.8v 369.495n 1.8v 369.505n 1.8v 379.495n 1.8v 379.505n 0.0v 389.495n 0.0v 389.505n 0.0v 399.495n 0.0v 399.505n 1.8v 409.495n 1.8v 409.505n 1.8v 419.495n 1.8v 419.505n 1.8v 429.495n 1.8v 429.505n 0.0v 439.495n 0.0v 439.505n 0.0v 449.495n 0.0v 449.505n 0.0v 459.495n 0.0v 459.505n 0.0v 469.495n 0.0v 469.505n 1.8v 479.495n 1.8v 479.505n 1.8v 489.495n 1.8v 489.505n 1.8v 499.495n 1.8v 499.505n 1.8v 509.495n 1.8v 509.505n 1.8v 519.495n 1.8v 519.505n 1.8v 529.495n 1.8v 529.505n 0.0v 539.495n 0.0v 539.505n 0.0v 549.495n 0.0v 549.505n 0.0v 559.495n 0.0v 559.505n 0.0v 569.495n 0.0v 569.505n 0.0v 579.495n 0.0v 579.505n 1.8v 589.495n 1.8v 589.505n 1.8v 599.495n 1.8v 599.505n 0.0v 609.495n 0.0v 609.505n 0.0v 619.495n 0.0v 619.505n 0.0v 629.495n 0.0v 629.505n 0.0v 639.495n 0.0v 639.505n 0.0v 649.495n 0.0v 649.505n 0.0v 659.495n 0.0v 659.505n 0.0v 669.495n 0.0v 669.505n 0.0v 679.495n 0.0v 679.505n 0.0v 689.495n 0.0v 689.505n 1.8v 699.495n 1.8v 699.505n 1.8v 709.495n 1.8v 709.505n 1.8v 719.495n 1.8v 719.505n 1.8v 729.495n 1.8v 729.505n 1.8v 739.495n 1.8v 739.505n 1.8v 749.495n 1.8v 749.505n 1.8v 759.495n 1.8v 759.505n 1.8v 769.495n 1.8v 769.505n 1.8v 779.495n 1.8v 779.505n 1.8v 789.495n 1.8v 789.505n 0.0v 799.495n 0.0v 799.505n 0.0v 809.495n 0.0v 809.505n 0.0v 819.495n 0.0v 819.505n 1.8v 829.495n 1.8v 829.505n 0.0v 839.495n 0.0v 839.505n 0.0v 849.495n 0.0v 849.505n 0.0v 859.495n 0.0v 859.505n 1.8v 869.495n 1.8v 869.505n 1.8v 879.495n 1.8v 879.505n 1.8v 889.495n 1.8v 889.505n 1.8v 899.495n 1.8v 899.505n 1.8v 909.495n 1.8v 909.505n 0.0v 919.495n 0.0v 919.505n 0.0v 929.495n 0.0v 929.505n 0.0v 939.495n 0.0v 939.505n 1.8v 949.495n 1.8v 949.505n 1.8v 959.495n 1.8v 959.505n 1.8v 969.495n 1.8v 969.505n 1.8v 979.495n 1.8v 979.505n 1.8v 989.495n 1.8v 989.505n 1.8v 999.495n 1.8v 999.505n 1.8v 1009.495n 1.8v 1009.505n 1.8v 1019.495n 1.8v 1019.505n 1.8v 1029.495n 1.8v 1029.505n 1.8v 1039.495n 1.8v 1039.505n 0.0v 1049.495n 0.0v 1049.505n 0.0v 1059.495n 0.0v 1059.505n 1.8v 1069.495n 1.8v 1069.505n 1.8v 1079.495n 1.8v 1079.505n 0.0v 1089.495n 0.0v 1089.505n 0.0v 1099.495n 0.0v 1099.505n 0.0v 1109.495n 0.0v 1109.505n 1.8v 1119.495n 1.8v 1119.505n 1.8v 1129.495n 1.8v 1129.505n 1.8v 1139.495n 1.8v 1139.505n 1.8v 1149.495n 1.8v 1149.505n 1.8v 1159.495n 1.8v 1159.505n 1.8v 1169.495n 1.8v 1169.505n 1.8v 1179.495n 1.8v 1179.505n 0.0v 1189.495n 0.0v 1189.505n 0.0v 1199.495n 0.0v 1199.505n 0.0v 1209.495n 0.0v 1209.505n 0.0v 1219.495n 0.0v 1219.505n 0.0v 1229.495n 0.0v 1229.505n 0.0v 1239.495n 0.0v 1239.505n 0.0v 1249.495n 0.0v 1249.505n 0.0v 1259.495n 0.0v 1259.505n 0.0v 1269.495n 0.0v 1269.505n 0.0v 1279.495n 0.0v 1279.505n 0.0v 1289.495n 0.0v 1289.505n 1.8v 1299.495n 1.8v 1299.505n 1.8v 1309.495n 1.8v 1309.505n 0.0v 1319.495n 0.0v 1319.505n 0.0v 1329.495n 0.0v 1329.505n 0.0v 1339.495n 0.0v 1339.505n 0.0v 1349.495n 0.0v 1349.505n 0.0v 1359.495n 0.0v 1359.505n 0.0v 1369.495n 0.0v 1369.505n 0.0v 1379.495n 0.0v 1379.505n 0.0v 1389.495n 0.0v 1389.505n 0.0v 1399.495n 0.0v 1399.505n 0.0v 1409.495n 0.0v 1409.505n 1.8v 1419.495n 1.8v 1419.505n 0.0v 1429.495n 0.0v 1429.505n 1.8v 1439.495n 1.8v 1439.505n 1.8v 1449.495n 1.8v 1449.505n 1.8v 1459.495n 1.8v 1459.505n 1.8v 1469.495n 1.8v 1469.505n 1.8v 1479.495n 1.8v 1479.505n 1.8v 1489.495n 1.8v 1489.505n 1.8v 1499.495n 1.8v 1499.505n 1.8v 1509.495n 1.8v 1509.505n 1.8v 1519.495n 1.8v 1519.505n 1.8v 1529.495n 1.8v 1529.505n 1.8v 1539.495n 1.8v 1539.505n 1.8v 1549.495n 1.8v 1549.505n 1.8v 1559.495n 1.8v 1559.505n 0.0v 1569.495n 0.0v 1569.505n 0.0v 1579.495n 0.0v 1579.505n 0.0v 1589.495n 0.0v 1589.505n 0.0v 1599.495n 0.0v 1599.505n 0.0v 1609.495n 0.0v 1609.505n 0.0v 1619.495n 0.0v 1619.505n 0.0v 1629.495n 0.0v 1629.505n 0.0v 1639.495n 0.0v 1639.505n 0.0v 1649.495n 0.0v 1649.505n 0.0v 1659.495n 0.0v 1659.505n 0.0v 1669.495n 0.0v 1669.505n 0.0v 1679.495n 0.0v 1679.505n 1.8v 1689.495n 1.8v 1689.505n 1.8v 1699.495n 1.8v 1699.505n 0.0v 1709.495n 0.0v 1709.505n 0.0v 1719.495n 0.0v 1719.505n 0.0v 1729.495n 0.0v 1729.505n 1.8v 1739.495n 1.8v 1739.505n 0.0v 1749.495n 0.0v 1749.505n 0.0v 1759.495n 0.0v 1759.505n 0.0v 1769.495n 0.0v 1769.505n 0.0v 1779.495n 0.0v 1779.505n 0.0v 1789.495n 0.0v 1789.505n 0.0v 1799.495n 0.0v 1799.505n 1.8v 1809.495n 1.8v 1809.505n 1.8v 1819.495n 1.8v 1819.505n 0.0v 1829.495n 0.0v 1829.505n 0.0v 1839.495n 0.0v 1839.505n 1.8v 1849.495n 1.8v 1849.505n 1.8v 1859.495n 1.8v 1859.505n 1.8v 1869.495n 1.8v 1869.505n 0.0v 1879.495n 0.0v 1879.505n 0.0v 1889.495n 0.0v 1889.505n 0.0v 1899.495n 0.0v 1899.505n 0.0v 1909.495n 0.0v 1909.505n 0.0v 1919.495n 0.0v 1919.505n 0.0v 1929.495n 0.0v 1929.505n 0.0v 1939.495n 0.0v 1939.505n 0.0v 1949.495n 0.0v 1949.505n 0.0v 1959.495n 0.0v 1959.505n 1.8v 1969.495n 1.8v 1969.505n 1.8v 1979.495n 1.8v 1979.505n 1.8v 1989.495n 1.8v 1989.505n 1.8v 1999.495n 1.8v 1999.505n 1.8v 2009.495n 1.8v 2009.505n 0.0v 2019.495n 0.0v 2019.505n 0.0v 2029.495n 0.0v 2029.505n 0.0v 2039.495n 0.0v 2039.505n 0.0v 2049.495n 0.0v 2049.505n 0.0v )

 * Generation of control signals
* (time, data): [(0, 1), (10, 0), (20, 0), (30, 0), (40, 0), (50, 0), (60, 0), (70, 0), (80, 0), (90, 0), (100, 0), (110, 1), (120, 0), (130, 0), (140, 0), (150, 1), (160, 1), (170, 0), (180, 0), (190, 0), (200, 0), (210, 0), (220, 0), (230, 0), (240, 1), (250, 0), (260, 1), (270, 0), (280, 0), (290, 1), (300, 0), (310, 0), (320, 0), (330, 1), (340, 0), (350, 0), (360, 0), (370, 0), (380, 0), (390, 0), (400, 1), (410, 0), (420, 0), (430, 0), (440, 0), (450, 1), (460, 0), (470, 0), (480, 0), (490, 0), (500, 1), (510, 0), (520, 1), (530, 0), (540, 0), (550, 0), (560, 0), (570, 0), (580, 0), (590, 0), (600, 0), (610, 0), (620, 0), (630, 0), (640, 1), (650, 0), (660, 0), (670, 0), (680, 0), (690, 0), (700, 0), (710, 1), (720, 1), (730, 0), (740, 0), (750, 0), (760, 0), (770, 0), (780, 0), (790, 0), (800, 0), (810, 0), (820, 1), (830, 0), (840, 0), (850, 0), (860, 1), (870, 0), (880, 0), (890, 0), (900, 0), (910, 0), (920, 0), (930, 0), (940, 0), (950, 0), (960, 0), (970, 0), (980, 0), (990, 1), (1000, 0), (1010, 1), (1020, 0), (1030, 1), (1040, 1), (1050, 0), (1060, 0), (1070, 0), (1080, 0), (1090, 0), (1100, 1), (1110, 0), (1120, 0), (1130, 0), (1140, 0), (1150, 0), (1160, 0), (1170, 0), (1180, 0), (1190, 0), (1200, 0), (1210, 0), (1220, 1), (1230, 0), (1240, 0), (1250, 0), (1260, 0), (1270, 0), (1280, 0), (1290, 1), (1300, 1), (1310, 0), (1320, 0), (1330, 0), (1340, 0), (1350, 0), (1360, 0), (1370, 0), (1380, 0), (1390, 0), (1400, 1), (1410, 1), (1420, 0), (1430, 0), (1440, 0), (1450, 0), (1460, 0), (1470, 0), (1480, 0), (1490, 0), (1500, 1), (1510, 0), (1520, 0), (1530, 0), (1540, 0), (1550, 0), (1560, 0), (1570, 0), (1580, 0), (1590, 0), (1600, 0), (1610, 1), (1620, 0), (1630, 0), (1640, 0), (1650, 0), (1660, 0), (1670, 0), (1680, 0), (1690, 0), (1700, 1), (1710, 0), (1720, 0), (1730, 1), (1740, 1), (1750, 0), (1760, 0), (1770, 0), (1780, 0), (1790, 0), (1800, 0), (1810, 0), (1820, 0), (1830, 0), (1840, 0), (1850, 0), (1860, 0), (1870, 1), (1880, 0), (1890, 0), (1900, 0), (1910, 0), (1920, 1), (1930, 0), (1940, 0), (1950, 0), (1960, 1), (1970, 0), (1980, 0), (1990, 0), (2000, 0), (2010, 0), (2020, 0), (2030, 1), (2040, 1), (2050, 1)]
VCSB0 CSB0 0 PWL (0n 1.8v 9.495n 1.8v 9.505n 0.0v 19.495n 0.0v 19.505n 0.0v 29.495n 0.0v 29.505n 0.0v 39.495n 0.0v 39.505n 0.0v 49.495n 0.0v 49.505n 0.0v 59.495n 0.0v 59.505n 0.0v 69.495n 0.0v 69.505n 0.0v 79.495n 0.0v 79.505n 0.0v 89.495n 0.0v 89.505n 0.0v 99.495n 0.0v 99.505n 0.0v 109.495n 0.0v 109.505n 1.8v 119.495n 1.8v 119.505n 0.0v 129.495n 0.0v 129.505n 0.0v 139.495n 0.0v 139.505n 0.0v 149.495n 0.0v 149.505n 1.8v 159.495n 1.8v 159.505n 1.8v 169.495n 1.8v 169.505n 0.0v 179.495n 0.0v 179.505n 0.0v 189.495n 0.0v 189.505n 0.0v 199.495n 0.0v 199.505n 0.0v 209.495n 0.0v 209.505n 0.0v 219.495n 0.0v 219.505n 0.0v 229.495n 0.0v 229.505n 0.0v 239.495n 0.0v 239.505n 1.8v 249.495n 1.8v 249.505n 0.0v 259.495n 0.0v 259.505n 1.8v 269.495n 1.8v 269.505n 0.0v 279.495n 0.0v 279.505n 0.0v 289.495n 0.0v 289.505n 1.8v 299.495n 1.8v 299.505n 0.0v 309.495n 0.0v 309.505n 0.0v 319.495n 0.0v 319.505n 0.0v 329.495n 0.0v 329.505n 1.8v 339.495n 1.8v 339.505n 0.0v 349.495n 0.0v 349.505n 0.0v 359.495n 0.0v 359.505n 0.0v 369.495n 0.0v 369.505n 0.0v 379.495n 0.0v 379.505n 0.0v 389.495n 0.0v 389.505n 0.0v 399.495n 0.0v 399.505n 1.8v 409.495n 1.8v 409.505n 0.0v 419.495n 0.0v 419.505n 0.0v 429.495n 0.0v 429.505n 0.0v 439.495n 0.0v 439.505n 0.0v 449.495n 0.0v 449.505n 1.8v 459.495n 1.8v 459.505n 0.0v 469.495n 0.0v 469.505n 0.0v 479.495n 0.0v 479.505n 0.0v 489.495n 0.0v 489.505n 0.0v 499.495n 0.0v 499.505n 1.8v 509.495n 1.8v 509.505n 0.0v 519.495n 0.0v 519.505n 1.8v 529.495n 1.8v 529.505n 0.0v 539.495n 0.0v 539.505n 0.0v 549.495n 0.0v 549.505n 0.0v 559.495n 0.0v 559.505n 0.0v 569.495n 0.0v 569.505n 0.0v 579.495n 0.0v 579.505n 0.0v 589.495n 0.0v 589.505n 0.0v 599.495n 0.0v 599.505n 0.0v 609.495n 0.0v 609.505n 0.0v 619.495n 0.0v 619.505n 0.0v 629.495n 0.0v 629.505n 0.0v 639.495n 0.0v 639.505n 1.8v 649.495n 1.8v 649.505n 0.0v 659.495n 0.0v 659.505n 0.0v 669.495n 0.0v 669.505n 0.0v 679.495n 0.0v 679.505n 0.0v 689.495n 0.0v 689.505n 0.0v 699.495n 0.0v 699.505n 0.0v 709.495n 0.0v 709.505n 1.8v 719.495n 1.8v 719.505n 1.8v 729.495n 1.8v 729.505n 0.0v 739.495n 0.0v 739.505n 0.0v 749.495n 0.0v 749.505n 0.0v 759.495n 0.0v 759.505n 0.0v 769.495n 0.0v 769.505n 0.0v 779.495n 0.0v 779.505n 0.0v 789.495n 0.0v 789.505n 0.0v 799.495n 0.0v 799.505n 0.0v 809.495n 0.0v 809.505n 0.0v 819.495n 0.0v 819.505n 1.8v 829.495n 1.8v 829.505n 0.0v 839.495n 0.0v 839.505n 0.0v 849.495n 0.0v 849.505n 0.0v 859.495n 0.0v 859.505n 1.8v 869.495n 1.8v 869.505n 0.0v 879.495n 0.0v 879.505n 0.0v 889.495n 0.0v 889.505n 0.0v 899.495n 0.0v 899.505n 0.0v 909.495n 0.0v 909.505n 0.0v 919.495n 0.0v 919.505n 0.0v 929.495n 0.0v 929.505n 0.0v 939.495n 0.0v 939.505n 0.0v 949.495n 0.0v 949.505n 0.0v 959.495n 0.0v 959.505n 0.0v 969.495n 0.0v 969.505n 0.0v 979.495n 0.0v 979.505n 0.0v 989.495n 0.0v 989.505n 1.8v 999.495n 1.8v 999.505n 0.0v 1009.495n 0.0v 1009.505n 1.8v 1019.495n 1.8v 1019.505n 0.0v 1029.495n 0.0v 1029.505n 1.8v 1039.495n 1.8v 1039.505n 1.8v 1049.495n 1.8v 1049.505n 0.0v 1059.495n 0.0v 1059.505n 0.0v 1069.495n 0.0v 1069.505n 0.0v 1079.495n 0.0v 1079.505n 0.0v 1089.495n 0.0v 1089.505n 0.0v 1099.495n 0.0v 1099.505n 1.8v 1109.495n 1.8v 1109.505n 0.0v 1119.495n 0.0v 1119.505n 0.0v 1129.495n 0.0v 1129.505n 0.0v 1139.495n 0.0v 1139.505n 0.0v 1149.495n 0.0v 1149.505n 0.0v 1159.495n 0.0v 1159.505n 0.0v 1169.495n 0.0v 1169.505n 0.0v 1179.495n 0.0v 1179.505n 0.0v 1189.495n 0.0v 1189.505n 0.0v 1199.495n 0.0v 1199.505n 0.0v 1209.495n 0.0v 1209.505n 0.0v 1219.495n 0.0v 1219.505n 1.8v 1229.495n 1.8v 1229.505n 0.0v 1239.495n 0.0v 1239.505n 0.0v 1249.495n 0.0v 1249.505n 0.0v 1259.495n 0.0v 1259.505n 0.0v 1269.495n 0.0v 1269.505n 0.0v 1279.495n 0.0v 1279.505n 0.0v 1289.495n 0.0v 1289.505n 1.8v 1299.495n 1.8v 1299.505n 1.8v 1309.495n 1.8v 1309.505n 0.0v 1319.495n 0.0v 1319.505n 0.0v 1329.495n 0.0v 1329.505n 0.0v 1339.495n 0.0v 1339.505n 0.0v 1349.495n 0.0v 1349.505n 0.0v 1359.495n 0.0v 1359.505n 0.0v 1369.495n 0.0v 1369.505n 0.0v 1379.495n 0.0v 1379.505n 0.0v 1389.495n 0.0v 1389.505n 0.0v 1399.495n 0.0v 1399.505n 1.8v 1409.495n 1.8v 1409.505n 1.8v 1419.495n 1.8v 1419.505n 0.0v 1429.495n 0.0v 1429.505n 0.0v 1439.495n 0.0v 1439.505n 0.0v 1449.495n 0.0v 1449.505n 0.0v 1459.495n 0.0v 1459.505n 0.0v 1469.495n 0.0v 1469.505n 0.0v 1479.495n 0.0v 1479.505n 0.0v 1489.495n 0.0v 1489.505n 0.0v 1499.495n 0.0v 1499.505n 1.8v 1509.495n 1.8v 1509.505n 0.0v 1519.495n 0.0v 1519.505n 0.0v 1529.495n 0.0v 1529.505n 0.0v 1539.495n 0.0v 1539.505n 0.0v 1549.495n 0.0v 1549.505n 0.0v 1559.495n 0.0v 1559.505n 0.0v 1569.495n 0.0v 1569.505n 0.0v 1579.495n 0.0v 1579.505n 0.0v 1589.495n 0.0v 1589.505n 0.0v 1599.495n 0.0v 1599.505n 0.0v 1609.495n 0.0v 1609.505n 1.8v 1619.495n 1.8v 1619.505n 0.0v 1629.495n 0.0v 1629.505n 0.0v 1639.495n 0.0v 1639.505n 0.0v 1649.495n 0.0v 1649.505n 0.0v 1659.495n 0.0v 1659.505n 0.0v 1669.495n 0.0v 1669.505n 0.0v 1679.495n 0.0v 1679.505n 0.0v 1689.495n 0.0v 1689.505n 0.0v 1699.495n 0.0v 1699.505n 1.8v 1709.495n 1.8v 1709.505n 0.0v 1719.495n 0.0v 1719.505n 0.0v 1729.495n 0.0v 1729.505n 1.8v 1739.495n 1.8v 1739.505n 1.8v 1749.495n 1.8v 1749.505n 0.0v 1759.495n 0.0v 1759.505n 0.0v 1769.495n 0.0v 1769.505n 0.0v 1779.495n 0.0v 1779.505n 0.0v 1789.495n 0.0v 1789.505n 0.0v 1799.495n 0.0v 1799.505n 0.0v 1809.495n 0.0v 1809.505n 0.0v 1819.495n 0.0v 1819.505n 0.0v 1829.495n 0.0v 1829.505n 0.0v 1839.495n 0.0v 1839.505n 0.0v 1849.495n 0.0v 1849.505n 0.0v 1859.495n 0.0v 1859.505n 0.0v 1869.495n 0.0v 1869.505n 1.8v 1879.495n 1.8v 1879.505n 0.0v 1889.495n 0.0v 1889.505n 0.0v 1899.495n 0.0v 1899.505n 0.0v 1909.495n 0.0v 1909.505n 0.0v 1919.495n 0.0v 1919.505n 1.8v 1929.495n 1.8v 1929.505n 0.0v 1939.495n 0.0v 1939.505n 0.0v 1949.495n 0.0v 1949.505n 0.0v 1959.495n 0.0v 1959.505n 1.8v 1969.495n 1.8v 1969.505n 0.0v 1979.495n 0.0v 1979.505n 0.0v 1989.495n 0.0v 1989.505n 0.0v 1999.495n 0.0v 1999.505n 0.0v 2009.495n 0.0v 2009.505n 0.0v 2019.495n 0.0v 2019.505n 0.0v 2029.495n 0.0v 2029.505n 1.8v 2039.495n 1.8v 2039.505n 1.8v 2049.495n 1.8v 2049.505n 1.8v )
* (time, data): [(0, 1), (10, 1), (20, 1), (30, 1), (40, 0), (50, 1), (60, 1), (70, 0), (80, 1), (90, 1), (100, 0), (110, 0), (120, 1), (130, 0), (140, 0), (150, 1), (160, 0), (170, 0), (180, 1), (190, 0), (200, 1), (210, 1), (220, 0), (230, 0), (240, 0), (250, 0), (260, 0), (270, 1), (280, 0), (290, 0), (300, 1), (310, 1), (320, 1), (330, 0), (340, 0), (350, 1), (360, 1), (370, 1), (380, 0), (390, 0), (400, 0), (410, 1), (420, 1), (430, 0), (440, 0), (450, 1), (460, 1), (470, 0), (480, 1), (490, 1), (500, 0), (510, 0), (520, 1), (530, 0), (540, 1), (550, 1), (560, 0), (570, 0), (580, 0), (590, 1), (600, 0), (610, 1), (620, 1), (630, 1), (640, 1), (650, 1), (660, 1), (670, 1), (680, 1), (690, 0), (700, 1), (710, 1), (720, 1), (730, 1), (740, 1), (750, 1), (760, 1), (770, 0), (780, 1), (790, 0), (800, 0), (810, 0), (820, 0), (830, 0), (840, 0), (850, 0), (860, 0), (870, 0), (880, 1), (890, 1), (900, 1), (910, 0), (920, 1), (930, 0), (940, 0), (950, 1), (960, 1), (970, 1), (980, 0), (990, 0), (1000, 1), (1010, 1), (1020, 1), (1030, 1), (1040, 0), (1050, 1), (1060, 0), (1070, 1), (1080, 0), (1090, 1), (1100, 0), (1110, 0), (1120, 1), (1130, 1), (1140, 1), (1150, 1), (1160, 1), (1170, 0), (1180, 0), (1190, 1), (1200, 1), (1210, 0), (1220, 1), (1230, 0), (1240, 1), (1250, 1), (1260, 1), (1270, 1), (1280, 1), (1290, 0), (1300, 1), (1310, 0), (1320, 0), (1330, 1), (1340, 0), (1350, 0), (1360, 1), (1370, 1), (1380, 0), (1390, 1), (1400, 1), (1410, 0), (1420, 0), (1430, 0), (1440, 1), (1450, 0), (1460, 1), (1470, 1), (1480, 0), (1490, 0), (1500, 0), (1510, 1), (1520, 0), (1530, 1), (1540, 1), (1550, 1), (1560, 0), (1570, 1), (1580, 0), (1590, 1), (1600, 1), (1610, 1), (1620, 0), (1630, 1), (1640, 0), (1650, 0), (1660, 0), (1670, 1), (1680, 0), (1690, 0), (1700, 0), (1710, 0), (1720, 1), (1730, 0), (1740, 0), (1750, 1), (1760, 0), (1770, 1), (1780, 1), (1790, 0), (1800, 0), (1810, 0), (1820, 0), (1830, 1), (1840, 0), (1850, 0), (1860, 1), (1870, 0), (1880, 0), (1890, 1), (1900, 0), (1910, 1), (1920, 0), (1930, 0), (1940, 1), (1950, 1), (1960, 0), (1970, 1), (1980, 0), (1990, 1), (2000, 1), (2010, 0), (2020, 0), (2030, 1), (2040, 1), (2050, 1)]
VCSB1 CSB1 0 PWL (0n 1.8v 9.495n 1.8v 9.505n 1.8v 19.495n 1.8v 19.505n 1.8v 29.495n 1.8v 29.505n 1.8v 39.495n 1.8v 39.505n 0.0v 49.495n 0.0v 49.505n 1.8v 59.495n 1.8v 59.505n 1.8v 69.495n 1.8v 69.505n 0.0v 79.495n 0.0v 79.505n 1.8v 89.495n 1.8v 89.505n 1.8v 99.495n 1.8v 99.505n 0.0v 109.495n 0.0v 109.505n 0.0v 119.495n 0.0v 119.505n 1.8v 129.495n 1.8v 129.505n 0.0v 139.495n 0.0v 139.505n 0.0v 149.495n 0.0v 149.505n 1.8v 159.495n 1.8v 159.505n 0.0v 169.495n 0.0v 169.505n 0.0v 179.495n 0.0v 179.505n 1.8v 189.495n 1.8v 189.505n 0.0v 199.495n 0.0v 199.505n 1.8v 209.495n 1.8v 209.505n 1.8v 219.495n 1.8v 219.505n 0.0v 229.495n 0.0v 229.505n 0.0v 239.495n 0.0v 239.505n 0.0v 249.495n 0.0v 249.505n 0.0v 259.495n 0.0v 259.505n 0.0v 269.495n 0.0v 269.505n 1.8v 279.495n 1.8v 279.505n 0.0v 289.495n 0.0v 289.505n 0.0v 299.495n 0.0v 299.505n 1.8v 309.495n 1.8v 309.505n 1.8v 319.495n 1.8v 319.505n 1.8v 329.495n 1.8v 329.505n 0.0v 339.495n 0.0v 339.505n 0.0v 349.495n 0.0v 349.505n 1.8v 359.495n 1.8v 359.505n 1.8v 369.495n 1.8v 369.505n 1.8v 379.495n 1.8v 379.505n 0.0v 389.495n 0.0v 389.505n 0.0v 399.495n 0.0v 399.505n 0.0v 409.495n 0.0v 409.505n 1.8v 419.495n 1.8v 419.505n 1.8v 429.495n 1.8v 429.505n 0.0v 439.495n 0.0v 439.505n 0.0v 449.495n 0.0v 449.505n 1.8v 459.495n 1.8v 459.505n 1.8v 469.495n 1.8v 469.505n 0.0v 479.495n 0.0v 479.505n 1.8v 489.495n 1.8v 489.505n 1.8v 499.495n 1.8v 499.505n 0.0v 509.495n 0.0v 509.505n 0.0v 519.495n 0.0v 519.505n 1.8v 529.495n 1.8v 529.505n 0.0v 539.495n 0.0v 539.505n 1.8v 549.495n 1.8v 549.505n 1.8v 559.495n 1.8v 559.505n 0.0v 569.495n 0.0v 569.505n 0.0v 579.495n 0.0v 579.505n 0.0v 589.495n 0.0v 589.505n 1.8v 599.495n 1.8v 599.505n 0.0v 609.495n 0.0v 609.505n 1.8v 619.495n 1.8v 619.505n 1.8v 629.495n 1.8v 629.505n 1.8v 639.495n 1.8v 639.505n 1.8v 649.495n 1.8v 649.505n 1.8v 659.495n 1.8v 659.505n 1.8v 669.495n 1.8v 669.505n 1.8v 679.495n 1.8v 679.505n 1.8v 689.495n 1.8v 689.505n 0.0v 699.495n 0.0v 699.505n 1.8v 709.495n 1.8v 709.505n 1.8v 719.495n 1.8v 719.505n 1.8v 729.495n 1.8v 729.505n 1.8v 739.495n 1.8v 739.505n 1.8v 749.495n 1.8v 749.505n 1.8v 759.495n 1.8v 759.505n 1.8v 769.495n 1.8v 769.505n 0.0v 779.495n 0.0v 779.505n 1.8v 789.495n 1.8v 789.505n 0.0v 799.495n 0.0v 799.505n 0.0v 809.495n 0.0v 809.505n 0.0v 819.495n 0.0v 819.505n 0.0v 829.495n 0.0v 829.505n 0.0v 839.495n 0.0v 839.505n 0.0v 849.495n 0.0v 849.505n 0.0v 859.495n 0.0v 859.505n 0.0v 869.495n 0.0v 869.505n 0.0v 879.495n 0.0v 879.505n 1.8v 889.495n 1.8v 889.505n 1.8v 899.495n 1.8v 899.505n 1.8v 909.495n 1.8v 909.505n 0.0v 919.495n 0.0v 919.505n 1.8v 929.495n 1.8v 929.505n 0.0v 939.495n 0.0v 939.505n 0.0v 949.495n 0.0v 949.505n 1.8v 959.495n 1.8v 959.505n 1.8v 969.495n 1.8v 969.505n 1.8v 979.495n 1.8v 979.505n 0.0v 989.495n 0.0v 989.505n 0.0v 999.495n 0.0v 999.505n 1.8v 1009.495n 1.8v 1009.505n 1.8v 1019.495n 1.8v 1019.505n 1.8v 1029.495n 1.8v 1029.505n 1.8v 1039.495n 1.8v 1039.505n 0.0v 1049.495n 0.0v 1049.505n 1.8v 1059.495n 1.8v 1059.505n 0.0v 1069.495n 0.0v 1069.505n 1.8v 1079.495n 1.8v 1079.505n 0.0v 1089.495n 0.0v 1089.505n 1.8v 1099.495n 1.8v 1099.505n 0.0v 1109.495n 0.0v 1109.505n 0.0v 1119.495n 0.0v 1119.505n 1.8v 1129.495n 1.8v 1129.505n 1.8v 1139.495n 1.8v 1139.505n 1.8v 1149.495n 1.8v 1149.505n 1.8v 1159.495n 1.8v 1159.505n 1.8v 1169.495n 1.8v 1169.505n 0.0v 1179.495n 0.0v 1179.505n 0.0v 1189.495n 0.0v 1189.505n 1.8v 1199.495n 1.8v 1199.505n 1.8v 1209.495n 1.8v 1209.505n 0.0v 1219.495n 0.0v 1219.505n 1.8v 1229.495n 1.8v 1229.505n 0.0v 1239.495n 0.0v 1239.505n 1.8v 1249.495n 1.8v 1249.505n 1.8v 1259.495n 1.8v 1259.505n 1.8v 1269.495n 1.8v 1269.505n 1.8v 1279.495n 1.8v 1279.505n 1.8v 1289.495n 1.8v 1289.505n 0.0v 1299.495n 0.0v 1299.505n 1.8v 1309.495n 1.8v 1309.505n 0.0v 1319.495n 0.0v 1319.505n 0.0v 1329.495n 0.0v 1329.505n 1.8v 1339.495n 1.8v 1339.505n 0.0v 1349.495n 0.0v 1349.505n 0.0v 1359.495n 0.0v 1359.505n 1.8v 1369.495n 1.8v 1369.505n 1.8v 1379.495n 1.8v 1379.505n 0.0v 1389.495n 0.0v 1389.505n 1.8v 1399.495n 1.8v 1399.505n 1.8v 1409.495n 1.8v 1409.505n 0.0v 1419.495n 0.0v 1419.505n 0.0v 1429.495n 0.0v 1429.505n 0.0v 1439.495n 0.0v 1439.505n 1.8v 1449.495n 1.8v 1449.505n 0.0v 1459.495n 0.0v 1459.505n 1.8v 1469.495n 1.8v 1469.505n 1.8v 1479.495n 1.8v 1479.505n 0.0v 1489.495n 0.0v 1489.505n 0.0v 1499.495n 0.0v 1499.505n 0.0v 1509.495n 0.0v 1509.505n 1.8v 1519.495n 1.8v 1519.505n 0.0v 1529.495n 0.0v 1529.505n 1.8v 1539.495n 1.8v 1539.505n 1.8v 1549.495n 1.8v 1549.505n 1.8v 1559.495n 1.8v 1559.505n 0.0v 1569.495n 0.0v 1569.505n 1.8v 1579.495n 1.8v 1579.505n 0.0v 1589.495n 0.0v 1589.505n 1.8v 1599.495n 1.8v 1599.505n 1.8v 1609.495n 1.8v 1609.505n 1.8v 1619.495n 1.8v 1619.505n 0.0v 1629.495n 0.0v 1629.505n 1.8v 1639.495n 1.8v 1639.505n 0.0v 1649.495n 0.0v 1649.505n 0.0v 1659.495n 0.0v 1659.505n 0.0v 1669.495n 0.0v 1669.505n 1.8v 1679.495n 1.8v 1679.505n 0.0v 1689.495n 0.0v 1689.505n 0.0v 1699.495n 0.0v 1699.505n 0.0v 1709.495n 0.0v 1709.505n 0.0v 1719.495n 0.0v 1719.505n 1.8v 1729.495n 1.8v 1729.505n 0.0v 1739.495n 0.0v 1739.505n 0.0v 1749.495n 0.0v 1749.505n 1.8v 1759.495n 1.8v 1759.505n 0.0v 1769.495n 0.0v 1769.505n 1.8v 1779.495n 1.8v 1779.505n 1.8v 1789.495n 1.8v 1789.505n 0.0v 1799.495n 0.0v 1799.505n 0.0v 1809.495n 0.0v 1809.505n 0.0v 1819.495n 0.0v 1819.505n 0.0v 1829.495n 0.0v 1829.505n 1.8v 1839.495n 1.8v 1839.505n 0.0v 1849.495n 0.0v 1849.505n 0.0v 1859.495n 0.0v 1859.505n 1.8v 1869.495n 1.8v 1869.505n 0.0v 1879.495n 0.0v 1879.505n 0.0v 1889.495n 0.0v 1889.505n 1.8v 1899.495n 1.8v 1899.505n 0.0v 1909.495n 0.0v 1909.505n 1.8v 1919.495n 1.8v 1919.505n 0.0v 1929.495n 0.0v 1929.505n 0.0v 1939.495n 0.0v 1939.505n 1.8v 1949.495n 1.8v 1949.505n 1.8v 1959.495n 1.8v 1959.505n 0.0v 1969.495n 0.0v 1969.505n 1.8v 1979.495n 1.8v 1979.505n 0.0v 1989.495n 0.0v 1989.505n 1.8v 1999.495n 1.8v 1999.505n 1.8v 2009.495n 1.8v 2009.505n 0.0v 2019.495n 0.0v 2019.505n 0.0v 2029.495n 0.0v 2029.505n 1.8v 2039.495n 1.8v 2039.505n 1.8v 2049.495n 1.8v 2049.505n 1.8v )
* (time, data): [(0, 1), (10, 0), (20, 0), (30, 0), (40, 1), (50, 1), (60, 0), (70, 1), (80, 1), (90, 0), (100, 1), (110, 1), (120, 0), (130, 1), (140, 1), (150, 1), (160, 1), (170, 1), (180, 1), (190, 1), (200, 0), (210, 1), (220, 0), (230, 1), (240, 1), (250, 0), (260, 1), (270, 1), (280, 1), (290, 1), (300, 1), (310, 1), (320, 0), (330, 1), (340, 1), (350, 1), (360, 0), (370, 1), (380, 0), (390, 1), (400, 1), (410, 0), (420, 0), (430, 1), (440, 0), (450, 1), (460, 1), (470, 1), (480, 1), (490, 0), (500, 1), (510, 0), (520, 1), (530, 0), (540, 0), (550, 0), (560, 1), (570, 1), (580, 0), (590, 0), (600, 1), (610, 1), (620, 1), (630, 0), (640, 1), (650, 1), (660, 0), (670, 0), (680, 1), (690, 1), (700, 0), (710, 1), (720, 1), (730, 0), (740, 0), (750, 1), (760, 0), (770, 0), (780, 0), (790, 1), (800, 0), (810, 1), (820, 1), (830, 1), (840, 0), (850, 1), (860, 1), (870, 0), (880, 1), (890, 1), (900, 1), (910, 1), (920, 0), (930, 1), (940, 1), (950, 1), (960, 1), (970, 0), (980, 0), (990, 1), (1000, 0), (1010, 1), (1020, 0), (1030, 1), (1040, 1), (1050, 1), (1060, 1), (1070, 1), (1080, 1), (1090, 1), (1100, 1), (1110, 1), (1120, 0), (1130, 1), (1140, 0), (1150, 1), (1160, 0), (1170, 0), (1180, 1), (1190, 1), (1200, 0), (1210, 1), (1220, 1), (1230, 0), (1240, 0), (1250, 0), (1260, 0), (1270, 0), (1280, 1), (1290, 1), (1300, 1), (1310, 1), (1320, 0), (1330, 0), (1340, 0), (1350, 0), (1360, 0), (1370, 0), (1380, 1), (1390, 1), (1400, 1), (1410, 1), (1420, 1), (1430, 1), (1440, 0), (1450, 1), (1460, 0), (1470, 0), (1480, 1), (1490, 1), (1500, 1), (1510, 1), (1520, 1), (1530, 1), (1540, 1), (1550, 0), (1560, 0), (1570, 1), (1580, 1), (1590, 0), (1600, 1), (1610, 1), (1620, 1), (1630, 1), (1640, 0), (1650, 1), (1660, 1), (1670, 1), (1680, 1), (1690, 1), (1700, 1), (1710, 1), (1720, 0), (1730, 1), (1740, 1), (1750, 1), (1760, 1), (1770, 0), (1780, 0), (1790, 0), (1800, 0), (1810, 0), (1820, 1), (1830, 1), (1840, 1), (1850, 1), (1860, 1), (1870, 1), (1880, 0), (1890, 1), (1900, 0), (1910, 0), (1920, 1), (1930, 0), (1940, 1), (1950, 1), (1960, 1), (1970, 1), (1980, 0), (1990, 1), (2000, 1), (2010, 0), (2020, 1), (2030, 1), (2040, 1), (2050, 1)]
VWEB0 WEB0 0 PWL (0n 1.8v 9.495n 1.8v 9.505n 0.0v 19.495n 0.0v 19.505n 0.0v 29.495n 0.0v 29.505n 0.0v 39.495n 0.0v 39.505n 1.8v 49.495n 1.8v 49.505n 1.8v 59.495n 1.8v 59.505n 0.0v 69.495n 0.0v 69.505n 1.8v 79.495n 1.8v 79.505n 1.8v 89.495n 1.8v 89.505n 0.0v 99.495n 0.0v 99.505n 1.8v 109.495n 1.8v 109.505n 1.8v 119.495n 1.8v 119.505n 0.0v 129.495n 0.0v 129.505n 1.8v 139.495n 1.8v 139.505n 1.8v 149.495n 1.8v 149.505n 1.8v 159.495n 1.8v 159.505n 1.8v 169.495n 1.8v 169.505n 1.8v 179.495n 1.8v 179.505n 1.8v 189.495n 1.8v 189.505n 1.8v 199.495n 1.8v 199.505n 0.0v 209.495n 0.0v 209.505n 1.8v 219.495n 1.8v 219.505n 0.0v 229.495n 0.0v 229.505n 1.8v 239.495n 1.8v 239.505n 1.8v 249.495n 1.8v 249.505n 0.0v 259.495n 0.0v 259.505n 1.8v 269.495n 1.8v 269.505n 1.8v 279.495n 1.8v 279.505n 1.8v 289.495n 1.8v 289.505n 1.8v 299.495n 1.8v 299.505n 1.8v 309.495n 1.8v 309.505n 1.8v 319.495n 1.8v 319.505n 0.0v 329.495n 0.0v 329.505n 1.8v 339.495n 1.8v 339.505n 1.8v 349.495n 1.8v 349.505n 1.8v 359.495n 1.8v 359.505n 0.0v 369.495n 0.0v 369.505n 1.8v 379.495n 1.8v 379.505n 0.0v 389.495n 0.0v 389.505n 1.8v 399.495n 1.8v 399.505n 1.8v 409.495n 1.8v 409.505n 0.0v 419.495n 0.0v 419.505n 0.0v 429.495n 0.0v 429.505n 1.8v 439.495n 1.8v 439.505n 0.0v 449.495n 0.0v 449.505n 1.8v 459.495n 1.8v 459.505n 1.8v 469.495n 1.8v 469.505n 1.8v 479.495n 1.8v 479.505n 1.8v 489.495n 1.8v 489.505n 0.0v 499.495n 0.0v 499.505n 1.8v 509.495n 1.8v 509.505n 0.0v 519.495n 0.0v 519.505n 1.8v 529.495n 1.8v 529.505n 0.0v 539.495n 0.0v 539.505n 0.0v 549.495n 0.0v 549.505n 0.0v 559.495n 0.0v 559.505n 1.8v 569.495n 1.8v 569.505n 1.8v 579.495n 1.8v 579.505n 0.0v 589.495n 0.0v 589.505n 0.0v 599.495n 0.0v 599.505n 1.8v 609.495n 1.8v 609.505n 1.8v 619.495n 1.8v 619.505n 1.8v 629.495n 1.8v 629.505n 0.0v 639.495n 0.0v 639.505n 1.8v 649.495n 1.8v 649.505n 1.8v 659.495n 1.8v 659.505n 0.0v 669.495n 0.0v 669.505n 0.0v 679.495n 0.0v 679.505n 1.8v 689.495n 1.8v 689.505n 1.8v 699.495n 1.8v 699.505n 0.0v 709.495n 0.0v 709.505n 1.8v 719.495n 1.8v 719.505n 1.8v 729.495n 1.8v 729.505n 0.0v 739.495n 0.0v 739.505n 0.0v 749.495n 0.0v 749.505n 1.8v 759.495n 1.8v 759.505n 0.0v 769.495n 0.0v 769.505n 0.0v 779.495n 0.0v 779.505n 0.0v 789.495n 0.0v 789.505n 1.8v 799.495n 1.8v 799.505n 0.0v 809.495n 0.0v 809.505n 1.8v 819.495n 1.8v 819.505n 1.8v 829.495n 1.8v 829.505n 1.8v 839.495n 1.8v 839.505n 0.0v 849.495n 0.0v 849.505n 1.8v 859.495n 1.8v 859.505n 1.8v 869.495n 1.8v 869.505n 0.0v 879.495n 0.0v 879.505n 1.8v 889.495n 1.8v 889.505n 1.8v 899.495n 1.8v 899.505n 1.8v 909.495n 1.8v 909.505n 1.8v 919.495n 1.8v 919.505n 0.0v 929.495n 0.0v 929.505n 1.8v 939.495n 1.8v 939.505n 1.8v 949.495n 1.8v 949.505n 1.8v 959.495n 1.8v 959.505n 1.8v 969.495n 1.8v 969.505n 0.0v 979.495n 0.0v 979.505n 0.0v 989.495n 0.0v 989.505n 1.8v 999.495n 1.8v 999.505n 0.0v 1009.495n 0.0v 1009.505n 1.8v 1019.495n 1.8v 1019.505n 0.0v 1029.495n 0.0v 1029.505n 1.8v 1039.495n 1.8v 1039.505n 1.8v 1049.495n 1.8v 1049.505n 1.8v 1059.495n 1.8v 1059.505n 1.8v 1069.495n 1.8v 1069.505n 1.8v 1079.495n 1.8v 1079.505n 1.8v 1089.495n 1.8v 1089.505n 1.8v 1099.495n 1.8v 1099.505n 1.8v 1109.495n 1.8v 1109.505n 1.8v 1119.495n 1.8v 1119.505n 0.0v 1129.495n 0.0v 1129.505n 1.8v 1139.495n 1.8v 1139.505n 0.0v 1149.495n 0.0v 1149.505n 1.8v 1159.495n 1.8v 1159.505n 0.0v 1169.495n 0.0v 1169.505n 0.0v 1179.495n 0.0v 1179.505n 1.8v 1189.495n 1.8v 1189.505n 1.8v 1199.495n 1.8v 1199.505n 0.0v 1209.495n 0.0v 1209.505n 1.8v 1219.495n 1.8v 1219.505n 1.8v 1229.495n 1.8v 1229.505n 0.0v 1239.495n 0.0v 1239.505n 0.0v 1249.495n 0.0v 1249.505n 0.0v 1259.495n 0.0v 1259.505n 0.0v 1269.495n 0.0v 1269.505n 0.0v 1279.495n 0.0v 1279.505n 1.8v 1289.495n 1.8v 1289.505n 1.8v 1299.495n 1.8v 1299.505n 1.8v 1309.495n 1.8v 1309.505n 1.8v 1319.495n 1.8v 1319.505n 0.0v 1329.495n 0.0v 1329.505n 0.0v 1339.495n 0.0v 1339.505n 0.0v 1349.495n 0.0v 1349.505n 0.0v 1359.495n 0.0v 1359.505n 0.0v 1369.495n 0.0v 1369.505n 0.0v 1379.495n 0.0v 1379.505n 1.8v 1389.495n 1.8v 1389.505n 1.8v 1399.495n 1.8v 1399.505n 1.8v 1409.495n 1.8v 1409.505n 1.8v 1419.495n 1.8v 1419.505n 1.8v 1429.495n 1.8v 1429.505n 1.8v 1439.495n 1.8v 1439.505n 0.0v 1449.495n 0.0v 1449.505n 1.8v 1459.495n 1.8v 1459.505n 0.0v 1469.495n 0.0v 1469.505n 0.0v 1479.495n 0.0v 1479.505n 1.8v 1489.495n 1.8v 1489.505n 1.8v 1499.495n 1.8v 1499.505n 1.8v 1509.495n 1.8v 1509.505n 1.8v 1519.495n 1.8v 1519.505n 1.8v 1529.495n 1.8v 1529.505n 1.8v 1539.495n 1.8v 1539.505n 1.8v 1549.495n 1.8v 1549.505n 0.0v 1559.495n 0.0v 1559.505n 0.0v 1569.495n 0.0v 1569.505n 1.8v 1579.495n 1.8v 1579.505n 1.8v 1589.495n 1.8v 1589.505n 0.0v 1599.495n 0.0v 1599.505n 1.8v 1609.495n 1.8v 1609.505n 1.8v 1619.495n 1.8v 1619.505n 1.8v 1629.495n 1.8v 1629.505n 1.8v 1639.495n 1.8v 1639.505n 0.0v 1649.495n 0.0v 1649.505n 1.8v 1659.495n 1.8v 1659.505n 1.8v 1669.495n 1.8v 1669.505n 1.8v 1679.495n 1.8v 1679.505n 1.8v 1689.495n 1.8v 1689.505n 1.8v 1699.495n 1.8v 1699.505n 1.8v 1709.495n 1.8v 1709.505n 1.8v 1719.495n 1.8v 1719.505n 0.0v 1729.495n 0.0v 1729.505n 1.8v 1739.495n 1.8v 1739.505n 1.8v 1749.495n 1.8v 1749.505n 1.8v 1759.495n 1.8v 1759.505n 1.8v 1769.495n 1.8v 1769.505n 0.0v 1779.495n 0.0v 1779.505n 0.0v 1789.495n 0.0v 1789.505n 0.0v 1799.495n 0.0v 1799.505n 0.0v 1809.495n 0.0v 1809.505n 0.0v 1819.495n 0.0v 1819.505n 1.8v 1829.495n 1.8v 1829.505n 1.8v 1839.495n 1.8v 1839.505n 1.8v 1849.495n 1.8v 1849.505n 1.8v 1859.495n 1.8v 1859.505n 1.8v 1869.495n 1.8v 1869.505n 1.8v 1879.495n 1.8v 1879.505n 0.0v 1889.495n 0.0v 1889.505n 1.8v 1899.495n 1.8v 1899.505n 0.0v 1909.495n 0.0v 1909.505n 0.0v 1919.495n 0.0v 1919.505n 1.8v 1929.495n 1.8v 1929.505n 0.0v 1939.495n 0.0v 1939.505n 1.8v 1949.495n 1.8v 1949.505n 1.8v 1959.495n 1.8v 1959.505n 1.8v 1969.495n 1.8v 1969.505n 1.8v 1979.495n 1.8v 1979.505n 0.0v 1989.495n 0.0v 1989.505n 1.8v 1999.495n 1.8v 1999.505n 1.8v 2009.495n 1.8v 2009.505n 0.0v 2019.495n 0.0v 2019.505n 1.8v 2029.495n 1.8v 2029.505n 1.8v 2039.495n 1.8v 2039.505n 1.8v 2049.495n 1.8v 2049.505n 1.8v )

* Generation of wmask signals
* (time, data): [(0, 0), (10, 1), (20, 1), (30, 1), (40, 1), (50, 1), (60, 1), (70, 1), (80, 1), (90, 1), (100, 1), (110, 1), (120, 1), (130, 1), (140, 1), (150, 1), (160, 1), (170, 1), (180, 1), (190, 1), (200, 1), (210, 1), (220, 1), (230, 1), (240, 1), (250, 0), (260, 0), (270, 0), (280, 0), (290, 0), (300, 0), (310, 0), (320, 1), (330, 1), (340, 1), (350, 1), (360, 0), (370, 0), (380, 1), (390, 1), (400, 1), (410, 0), (420, 1), (430, 1), (440, 0), (450, 0), (460, 0), (470, 0), (480, 0), (490, 1), (500, 1), (510, 1), (520, 1), (530, 1), (540, 1), (550, 1), (560, 1), (570, 1), (580, 1), (590, 1), (600, 1), (610, 1), (620, 1), (630, 1), (640, 1), (650, 1), (660, 0), (670, 0), (680, 0), (690, 0), (700, 1), (710, 1), (720, 1), (730, 1), (740, 1), (750, 1), (760, 1), (770, 1), (780, 0), (790, 0), (800, 1), (810, 1), (820, 1), (830, 1), (840, 0), (850, 0), (860, 0), (870, 1), (880, 1), (890, 1), (900, 1), (910, 1), (920, 1), (930, 1), (940, 1), (950, 1), (960, 1), (970, 1), (980, 1), (990, 1), (1000, 1), (1010, 1), (1020, 1), (1030, 1), (1040, 1), (1050, 1), (1060, 1), (1070, 1), (1080, 1), (1090, 1), (1100, 1), (1110, 1), (1120, 1), (1130, 1), (1140, 0), (1150, 0), (1160, 1), (1170, 1), (1180, 1), (1190, 1), (1200, 1), (1210, 1), (1220, 1), (1230, 1), (1240, 1), (1250, 0), (1260, 1), (1270, 0), (1280, 0), (1290, 0), (1300, 0), (1310, 0), (1320, 1), (1330, 1), (1340, 1), (1350, 1), (1360, 1), (1370, 1), (1380, 1), (1390, 1), (1400, 1), (1410, 1), (1420, 1), (1430, 1), (1440, 1), (1450, 1), (1460, 1), (1470, 0), (1480, 0), (1490, 0), (1500, 0), (1510, 0), (1520, 0), (1530, 0), (1540, 0), (1550, 1), (1560, 1), (1570, 1), (1580, 1), (1590, 1), (1600, 1), (1610, 1), (1620, 1), (1630, 1), (1640, 0), (1650, 0), (1660, 0), (1670, 0), (1680, 0), (1690, 0), (1700, 0), (1710, 0), (1720, 1), (1730, 1), (1740, 1), (1750, 1), (1760, 1), (1770, 1), (1780, 1), (1790, 1), (1800, 1), (1810, 0), (1820, 0), (1830, 0), (1840, 0), (1850, 0), (1860, 0), (1870, 0), (1880, 1), (1890, 1), (1900, 0), (1910, 0), (1920, 0), (1930, 0), (1940, 0), (1950, 0), (1960, 0), (1970, 0), (1980, 0), (1990, 0), (2000, 0), (2010, 1), (2020, 1), (2030, 1), (2040, 1), (2050, 1)]
VWMASK0_0  WMASK0_0  0 PWL (0n 0.0v 9.495n 0.0v 9.505n 1.8v 19.495n 1.8v 19.505n 1.8v 29.495n 1.8v 29.505n 1.8v 39.495n 1.8v 39.505n 1.8v 49.495n 1.8v 49.505n 1.8v 59.495n 1.8v 59.505n 1.8v 69.495n 1.8v 69.505n 1.8v 79.495n 1.8v 79.505n 1.8v 89.495n 1.8v 89.505n 1.8v 99.495n 1.8v 99.505n 1.8v 109.495n 1.8v 109.505n 1.8v 119.495n 1.8v 119.505n 1.8v 129.495n 1.8v 129.505n 1.8v 139.495n 1.8v 139.505n 1.8v 149.495n 1.8v 149.505n 1.8v 159.495n 1.8v 159.505n 1.8v 169.495n 1.8v 169.505n 1.8v 179.495n 1.8v 179.505n 1.8v 189.495n 1.8v 189.505n 1.8v 199.495n 1.8v 199.505n 1.8v 209.495n 1.8v 209.505n 1.8v 219.495n 1.8v 219.505n 1.8v 229.495n 1.8v 229.505n 1.8v 239.495n 1.8v 239.505n 1.8v 249.495n 1.8v 249.505n 0.0v 259.495n 0.0v 259.505n 0.0v 269.495n 0.0v 269.505n 0.0v 279.495n 0.0v 279.505n 0.0v 289.495n 0.0v 289.505n 0.0v 299.495n 0.0v 299.505n 0.0v 309.495n 0.0v 309.505n 0.0v 319.495n 0.0v 319.505n 1.8v 329.495n 1.8v 329.505n 1.8v 339.495n 1.8v 339.505n 1.8v 349.495n 1.8v 349.505n 1.8v 359.495n 1.8v 359.505n 0.0v 369.495n 0.0v 369.505n 0.0v 379.495n 0.0v 379.505n 1.8v 389.495n 1.8v 389.505n 1.8v 399.495n 1.8v 399.505n 1.8v 409.495n 1.8v 409.505n 0.0v 419.495n 0.0v 419.505n 1.8v 429.495n 1.8v 429.505n 1.8v 439.495n 1.8v 439.505n 0.0v 449.495n 0.0v 449.505n 0.0v 459.495n 0.0v 459.505n 0.0v 469.495n 0.0v 469.505n 0.0v 479.495n 0.0v 479.505n 0.0v 489.495n 0.0v 489.505n 1.8v 499.495n 1.8v 499.505n 1.8v 509.495n 1.8v 509.505n 1.8v 519.495n 1.8v 519.505n 1.8v 529.495n 1.8v 529.505n 1.8v 539.495n 1.8v 539.505n 1.8v 549.495n 1.8v 549.505n 1.8v 559.495n 1.8v 559.505n 1.8v 569.495n 1.8v 569.505n 1.8v 579.495n 1.8v 579.505n 1.8v 589.495n 1.8v 589.505n 1.8v 599.495n 1.8v 599.505n 1.8v 609.495n 1.8v 609.505n 1.8v 619.495n 1.8v 619.505n 1.8v 629.495n 1.8v 629.505n 1.8v 639.495n 1.8v 639.505n 1.8v 649.495n 1.8v 649.505n 1.8v 659.495n 1.8v 659.505n 0.0v 669.495n 0.0v 669.505n 0.0v 679.495n 0.0v 679.505n 0.0v 689.495n 0.0v 689.505n 0.0v 699.495n 0.0v 699.505n 1.8v 709.495n 1.8v 709.505n 1.8v 719.495n 1.8v 719.505n 1.8v 729.495n 1.8v 729.505n 1.8v 739.495n 1.8v 739.505n 1.8v 749.495n 1.8v 749.505n 1.8v 759.495n 1.8v 759.505n 1.8v 769.495n 1.8v 769.505n 1.8v 779.495n 1.8v 779.505n 0.0v 789.495n 0.0v 789.505n 0.0v 799.495n 0.0v 799.505n 1.8v 809.495n 1.8v 809.505n 1.8v 819.495n 1.8v 819.505n 1.8v 829.495n 1.8v 829.505n 1.8v 839.495n 1.8v 839.505n 0.0v 849.495n 0.0v 849.505n 0.0v 859.495n 0.0v 859.505n 0.0v 869.495n 0.0v 869.505n 1.8v 879.495n 1.8v 879.505n 1.8v 889.495n 1.8v 889.505n 1.8v 899.495n 1.8v 899.505n 1.8v 909.495n 1.8v 909.505n 1.8v 919.495n 1.8v 919.505n 1.8v 929.495n 1.8v 929.505n 1.8v 939.495n 1.8v 939.505n 1.8v 949.495n 1.8v 949.505n 1.8v 959.495n 1.8v 959.505n 1.8v 969.495n 1.8v 969.505n 1.8v 979.495n 1.8v 979.505n 1.8v 989.495n 1.8v 989.505n 1.8v 999.495n 1.8v 999.505n 1.8v 1009.495n 1.8v 1009.505n 1.8v 1019.495n 1.8v 1019.505n 1.8v 1029.495n 1.8v 1029.505n 1.8v 1039.495n 1.8v 1039.505n 1.8v 1049.495n 1.8v 1049.505n 1.8v 1059.495n 1.8v 1059.505n 1.8v 1069.495n 1.8v 1069.505n 1.8v 1079.495n 1.8v 1079.505n 1.8v 1089.495n 1.8v 1089.505n 1.8v 1099.495n 1.8v 1099.505n 1.8v 1109.495n 1.8v 1109.505n 1.8v 1119.495n 1.8v 1119.505n 1.8v 1129.495n 1.8v 1129.505n 1.8v 1139.495n 1.8v 1139.505n 0.0v 1149.495n 0.0v 1149.505n 0.0v 1159.495n 0.0v 1159.505n 1.8v 1169.495n 1.8v 1169.505n 1.8v 1179.495n 1.8v 1179.505n 1.8v 1189.495n 1.8v 1189.505n 1.8v 1199.495n 1.8v 1199.505n 1.8v 1209.495n 1.8v 1209.505n 1.8v 1219.495n 1.8v 1219.505n 1.8v 1229.495n 1.8v 1229.505n 1.8v 1239.495n 1.8v 1239.505n 1.8v 1249.495n 1.8v 1249.505n 0.0v 1259.495n 0.0v 1259.505n 1.8v 1269.495n 1.8v 1269.505n 0.0v 1279.495n 0.0v 1279.505n 0.0v 1289.495n 0.0v 1289.505n 0.0v 1299.495n 0.0v 1299.505n 0.0v 1309.495n 0.0v 1309.505n 0.0v 1319.495n 0.0v 1319.505n 1.8v 1329.495n 1.8v 1329.505n 1.8v 1339.495n 1.8v 1339.505n 1.8v 1349.495n 1.8v 1349.505n 1.8v 1359.495n 1.8v 1359.505n 1.8v 1369.495n 1.8v 1369.505n 1.8v 1379.495n 1.8v 1379.505n 1.8v 1389.495n 1.8v 1389.505n 1.8v 1399.495n 1.8v 1399.505n 1.8v 1409.495n 1.8v 1409.505n 1.8v 1419.495n 1.8v 1419.505n 1.8v 1429.495n 1.8v 1429.505n 1.8v 1439.495n 1.8v 1439.505n 1.8v 1449.495n 1.8v 1449.505n 1.8v 1459.495n 1.8v 1459.505n 1.8v 1469.495n 1.8v 1469.505n 0.0v 1479.495n 0.0v 1479.505n 0.0v 1489.495n 0.0v 1489.505n 0.0v 1499.495n 0.0v 1499.505n 0.0v 1509.495n 0.0v 1509.505n 0.0v 1519.495n 0.0v 1519.505n 0.0v 1529.495n 0.0v 1529.505n 0.0v 1539.495n 0.0v 1539.505n 0.0v 1549.495n 0.0v 1549.505n 1.8v 1559.495n 1.8v 1559.505n 1.8v 1569.495n 1.8v 1569.505n 1.8v 1579.495n 1.8v 1579.505n 1.8v 1589.495n 1.8v 1589.505n 1.8v 1599.495n 1.8v 1599.505n 1.8v 1609.495n 1.8v 1609.505n 1.8v 1619.495n 1.8v 1619.505n 1.8v 1629.495n 1.8v 1629.505n 1.8v 1639.495n 1.8v 1639.505n 0.0v 1649.495n 0.0v 1649.505n 0.0v 1659.495n 0.0v 1659.505n 0.0v 1669.495n 0.0v 1669.505n 0.0v 1679.495n 0.0v 1679.505n 0.0v 1689.495n 0.0v 1689.505n 0.0v 1699.495n 0.0v 1699.505n 0.0v 1709.495n 0.0v 1709.505n 0.0v 1719.495n 0.0v 1719.505n 1.8v 1729.495n 1.8v 1729.505n 1.8v 1739.495n 1.8v 1739.505n 1.8v 1749.495n 1.8v 1749.505n 1.8v 1759.495n 1.8v 1759.505n 1.8v 1769.495n 1.8v 1769.505n 1.8v 1779.495n 1.8v 1779.505n 1.8v 1789.495n 1.8v 1789.505n 1.8v 1799.495n 1.8v 1799.505n 1.8v 1809.495n 1.8v 1809.505n 0.0v 1819.495n 0.0v 1819.505n 0.0v 1829.495n 0.0v 1829.505n 0.0v 1839.495n 0.0v 1839.505n 0.0v 1849.495n 0.0v 1849.505n 0.0v 1859.495n 0.0v 1859.505n 0.0v 1869.495n 0.0v 1869.505n 0.0v 1879.495n 0.0v 1879.505n 1.8v 1889.495n 1.8v 1889.505n 1.8v 1899.495n 1.8v 1899.505n 0.0v 1909.495n 0.0v 1909.505n 0.0v 1919.495n 0.0v 1919.505n 0.0v 1929.495n 0.0v 1929.505n 0.0v 1939.495n 0.0v 1939.505n 0.0v 1949.495n 0.0v 1949.505n 0.0v 1959.495n 0.0v 1959.505n 0.0v 1969.495n 0.0v 1969.505n 0.0v 1979.495n 0.0v 1979.505n 0.0v 1989.495n 0.0v 1989.505n 0.0v 1999.495n 0.0v 1999.505n 0.0v 2009.495n 0.0v 2009.505n 1.8v 2019.495n 1.8v 2019.505n 1.8v 2029.495n 1.8v 2029.505n 1.8v 2039.495n 1.8v 2039.505n 1.8v 2049.495n 1.8v 2049.505n 1.8v )
* (time, data): [(0, 0), (10, 1), (20, 1), (30, 1), (40, 1), (50, 1), (60, 1), (70, 1), (80, 1), (90, 1), (100, 1), (110, 1), (120, 0), (130, 0), (140, 0), (150, 0), (160, 0), (170, 0), (180, 0), (190, 0), (200, 1), (210, 1), (220, 1), (230, 1), (240, 1), (250, 1), (260, 1), (270, 1), (280, 1), (290, 1), (300, 1), (310, 1), (320, 0), (330, 0), (340, 0), (350, 0), (360, 0), (370, 0), (380, 1), (390, 1), (400, 1), (410, 1), (420, 1), (430, 1), (440, 1), (450, 1), (460, 1), (470, 1), (480, 1), (490, 1), (500, 1), (510, 1), (520, 1), (530, 1), (540, 0), (550, 1), (560, 1), (570, 1), (580, 1), (590, 0), (600, 0), (610, 0), (620, 0), (630, 1), (640, 1), (650, 1), (660, 0), (670, 0), (680, 0), (690, 0), (700, 1), (710, 1), (720, 1), (730, 1), (740, 1), (750, 1), (760, 0), (770, 0), (780, 1), (790, 1), (800, 1), (810, 1), (820, 1), (830, 1), (840, 1), (850, 1), (860, 1), (870, 1), (880, 1), (890, 1), (900, 1), (910, 1), (920, 1), (930, 1), (940, 1), (950, 1), (960, 1), (970, 1), (980, 1), (990, 1), (1000, 1), (1010, 1), (1020, 1), (1030, 1), (1040, 1), (1050, 1), (1060, 1), (1070, 1), (1080, 1), (1090, 1), (1100, 1), (1110, 1), (1120, 1), (1130, 1), (1140, 1), (1150, 1), (1160, 1), (1170, 1), (1180, 1), (1190, 1), (1200, 1), (1210, 1), (1220, 1), (1230, 1), (1240, 1), (1250, 0), (1260, 1), (1270, 0), (1280, 0), (1290, 0), (1300, 0), (1310, 0), (1320, 1), (1330, 1), (1340, 1), (1350, 1), (1360, 1), (1370, 1), (1380, 1), (1390, 1), (1400, 1), (1410, 1), (1420, 1), (1430, 1), (1440, 0), (1450, 0), (1460, 1), (1470, 1), (1480, 1), (1490, 1), (1500, 1), (1510, 1), (1520, 1), (1530, 1), (1540, 1), (1550, 0), (1560, 1), (1570, 1), (1580, 1), (1590, 1), (1600, 1), (1610, 1), (1620, 1), (1630, 1), (1640, 0), (1650, 0), (1660, 0), (1670, 0), (1680, 0), (1690, 0), (1700, 0), (1710, 0), (1720, 1), (1730, 1), (1740, 1), (1750, 1), (1760, 1), (1770, 1), (1780, 1), (1790, 1), (1800, 1), (1810, 0), (1820, 0), (1830, 0), (1840, 0), (1850, 0), (1860, 0), (1870, 0), (1880, 1), (1890, 1), (1900, 1), (1910, 1), (1920, 1), (1930, 0), (1940, 0), (1950, 0), (1960, 0), (1970, 0), (1980, 0), (1990, 0), (2000, 0), (2010, 1), (2020, 1), (2030, 1), (2040, 1), (2050, 1)]
VWMASK0_1  WMASK0_1  0 PWL (0n 0.0v 9.495n 0.0v 9.505n 1.8v 19.495n 1.8v 19.505n 1.8v 29.495n 1.8v 29.505n 1.8v 39.495n 1.8v 39.505n 1.8v 49.495n 1.8v 49.505n 1.8v 59.495n 1.8v 59.505n 1.8v 69.495n 1.8v 69.505n 1.8v 79.495n 1.8v 79.505n 1.8v 89.495n 1.8v 89.505n 1.8v 99.495n 1.8v 99.505n 1.8v 109.495n 1.8v 109.505n 1.8v 119.495n 1.8v 119.505n 0.0v 129.495n 0.0v 129.505n 0.0v 139.495n 0.0v 139.505n 0.0v 149.495n 0.0v 149.505n 0.0v 159.495n 0.0v 159.505n 0.0v 169.495n 0.0v 169.505n 0.0v 179.495n 0.0v 179.505n 0.0v 189.495n 0.0v 189.505n 0.0v 199.495n 0.0v 199.505n 1.8v 209.495n 1.8v 209.505n 1.8v 219.495n 1.8v 219.505n 1.8v 229.495n 1.8v 229.505n 1.8v 239.495n 1.8v 239.505n 1.8v 249.495n 1.8v 249.505n 1.8v 259.495n 1.8v 259.505n 1.8v 269.495n 1.8v 269.505n 1.8v 279.495n 1.8v 279.505n 1.8v 289.495n 1.8v 289.505n 1.8v 299.495n 1.8v 299.505n 1.8v 309.495n 1.8v 309.505n 1.8v 319.495n 1.8v 319.505n 0.0v 329.495n 0.0v 329.505n 0.0v 339.495n 0.0v 339.505n 0.0v 349.495n 0.0v 349.505n 0.0v 359.495n 0.0v 359.505n 0.0v 369.495n 0.0v 369.505n 0.0v 379.495n 0.0v 379.505n 1.8v 389.495n 1.8v 389.505n 1.8v 399.495n 1.8v 399.505n 1.8v 409.495n 1.8v 409.505n 1.8v 419.495n 1.8v 419.505n 1.8v 429.495n 1.8v 429.505n 1.8v 439.495n 1.8v 439.505n 1.8v 449.495n 1.8v 449.505n 1.8v 459.495n 1.8v 459.505n 1.8v 469.495n 1.8v 469.505n 1.8v 479.495n 1.8v 479.505n 1.8v 489.495n 1.8v 489.505n 1.8v 499.495n 1.8v 499.505n 1.8v 509.495n 1.8v 509.505n 1.8v 519.495n 1.8v 519.505n 1.8v 529.495n 1.8v 529.505n 1.8v 539.495n 1.8v 539.505n 0.0v 549.495n 0.0v 549.505n 1.8v 559.495n 1.8v 559.505n 1.8v 569.495n 1.8v 569.505n 1.8v 579.495n 1.8v 579.505n 1.8v 589.495n 1.8v 589.505n 0.0v 599.495n 0.0v 599.505n 0.0v 609.495n 0.0v 609.505n 0.0v 619.495n 0.0v 619.505n 0.0v 629.495n 0.0v 629.505n 1.8v 639.495n 1.8v 639.505n 1.8v 649.495n 1.8v 649.505n 1.8v 659.495n 1.8v 659.505n 0.0v 669.495n 0.0v 669.505n 0.0v 679.495n 0.0v 679.505n 0.0v 689.495n 0.0v 689.505n 0.0v 699.495n 0.0v 699.505n 1.8v 709.495n 1.8v 709.505n 1.8v 719.495n 1.8v 719.505n 1.8v 729.495n 1.8v 729.505n 1.8v 739.495n 1.8v 739.505n 1.8v 749.495n 1.8v 749.505n 1.8v 759.495n 1.8v 759.505n 0.0v 769.495n 0.0v 769.505n 0.0v 779.495n 0.0v 779.505n 1.8v 789.495n 1.8v 789.505n 1.8v 799.495n 1.8v 799.505n 1.8v 809.495n 1.8v 809.505n 1.8v 819.495n 1.8v 819.505n 1.8v 829.495n 1.8v 829.505n 1.8v 839.495n 1.8v 839.505n 1.8v 849.495n 1.8v 849.505n 1.8v 859.495n 1.8v 859.505n 1.8v 869.495n 1.8v 869.505n 1.8v 879.495n 1.8v 879.505n 1.8v 889.495n 1.8v 889.505n 1.8v 899.495n 1.8v 899.505n 1.8v 909.495n 1.8v 909.505n 1.8v 919.495n 1.8v 919.505n 1.8v 929.495n 1.8v 929.505n 1.8v 939.495n 1.8v 939.505n 1.8v 949.495n 1.8v 949.505n 1.8v 959.495n 1.8v 959.505n 1.8v 969.495n 1.8v 969.505n 1.8v 979.495n 1.8v 979.505n 1.8v 989.495n 1.8v 989.505n 1.8v 999.495n 1.8v 999.505n 1.8v 1009.495n 1.8v 1009.505n 1.8v 1019.495n 1.8v 1019.505n 1.8v 1029.495n 1.8v 1029.505n 1.8v 1039.495n 1.8v 1039.505n 1.8v 1049.495n 1.8v 1049.505n 1.8v 1059.495n 1.8v 1059.505n 1.8v 1069.495n 1.8v 1069.505n 1.8v 1079.495n 1.8v 1079.505n 1.8v 1089.495n 1.8v 1089.505n 1.8v 1099.495n 1.8v 1099.505n 1.8v 1109.495n 1.8v 1109.505n 1.8v 1119.495n 1.8v 1119.505n 1.8v 1129.495n 1.8v 1129.505n 1.8v 1139.495n 1.8v 1139.505n 1.8v 1149.495n 1.8v 1149.505n 1.8v 1159.495n 1.8v 1159.505n 1.8v 1169.495n 1.8v 1169.505n 1.8v 1179.495n 1.8v 1179.505n 1.8v 1189.495n 1.8v 1189.505n 1.8v 1199.495n 1.8v 1199.505n 1.8v 1209.495n 1.8v 1209.505n 1.8v 1219.495n 1.8v 1219.505n 1.8v 1229.495n 1.8v 1229.505n 1.8v 1239.495n 1.8v 1239.505n 1.8v 1249.495n 1.8v 1249.505n 0.0v 1259.495n 0.0v 1259.505n 1.8v 1269.495n 1.8v 1269.505n 0.0v 1279.495n 0.0v 1279.505n 0.0v 1289.495n 0.0v 1289.505n 0.0v 1299.495n 0.0v 1299.505n 0.0v 1309.495n 0.0v 1309.505n 0.0v 1319.495n 0.0v 1319.505n 1.8v 1329.495n 1.8v 1329.505n 1.8v 1339.495n 1.8v 1339.505n 1.8v 1349.495n 1.8v 1349.505n 1.8v 1359.495n 1.8v 1359.505n 1.8v 1369.495n 1.8v 1369.505n 1.8v 1379.495n 1.8v 1379.505n 1.8v 1389.495n 1.8v 1389.505n 1.8v 1399.495n 1.8v 1399.505n 1.8v 1409.495n 1.8v 1409.505n 1.8v 1419.495n 1.8v 1419.505n 1.8v 1429.495n 1.8v 1429.505n 1.8v 1439.495n 1.8v 1439.505n 0.0v 1449.495n 0.0v 1449.505n 0.0v 1459.495n 0.0v 1459.505n 1.8v 1469.495n 1.8v 1469.505n 1.8v 1479.495n 1.8v 1479.505n 1.8v 1489.495n 1.8v 1489.505n 1.8v 1499.495n 1.8v 1499.505n 1.8v 1509.495n 1.8v 1509.505n 1.8v 1519.495n 1.8v 1519.505n 1.8v 1529.495n 1.8v 1529.505n 1.8v 1539.495n 1.8v 1539.505n 1.8v 1549.495n 1.8v 1549.505n 0.0v 1559.495n 0.0v 1559.505n 1.8v 1569.495n 1.8v 1569.505n 1.8v 1579.495n 1.8v 1579.505n 1.8v 1589.495n 1.8v 1589.505n 1.8v 1599.495n 1.8v 1599.505n 1.8v 1609.495n 1.8v 1609.505n 1.8v 1619.495n 1.8v 1619.505n 1.8v 1629.495n 1.8v 1629.505n 1.8v 1639.495n 1.8v 1639.505n 0.0v 1649.495n 0.0v 1649.505n 0.0v 1659.495n 0.0v 1659.505n 0.0v 1669.495n 0.0v 1669.505n 0.0v 1679.495n 0.0v 1679.505n 0.0v 1689.495n 0.0v 1689.505n 0.0v 1699.495n 0.0v 1699.505n 0.0v 1709.495n 0.0v 1709.505n 0.0v 1719.495n 0.0v 1719.505n 1.8v 1729.495n 1.8v 1729.505n 1.8v 1739.495n 1.8v 1739.505n 1.8v 1749.495n 1.8v 1749.505n 1.8v 1759.495n 1.8v 1759.505n 1.8v 1769.495n 1.8v 1769.505n 1.8v 1779.495n 1.8v 1779.505n 1.8v 1789.495n 1.8v 1789.505n 1.8v 1799.495n 1.8v 1799.505n 1.8v 1809.495n 1.8v 1809.505n 0.0v 1819.495n 0.0v 1819.505n 0.0v 1829.495n 0.0v 1829.505n 0.0v 1839.495n 0.0v 1839.505n 0.0v 1849.495n 0.0v 1849.505n 0.0v 1859.495n 0.0v 1859.505n 0.0v 1869.495n 0.0v 1869.505n 0.0v 1879.495n 0.0v 1879.505n 1.8v 1889.495n 1.8v 1889.505n 1.8v 1899.495n 1.8v 1899.505n 1.8v 1909.495n 1.8v 1909.505n 1.8v 1919.495n 1.8v 1919.505n 1.8v 1929.495n 1.8v 1929.505n 0.0v 1939.495n 0.0v 1939.505n 0.0v 1949.495n 0.0v 1949.505n 0.0v 1959.495n 0.0v 1959.505n 0.0v 1969.495n 0.0v 1969.505n 0.0v 1979.495n 0.0v 1979.505n 0.0v 1989.495n 0.0v 1989.505n 0.0v 1999.495n 0.0v 1999.505n 0.0v 2009.495n 0.0v 2009.505n 1.8v 2019.495n 1.8v 2019.505n 1.8v 2029.495n 1.8v 2029.505n 1.8v 2039.495n 1.8v 2039.505n 1.8v 2049.495n 1.8v 2049.505n 1.8v )
* (time, data): [(0, 0), (10, 1), (20, 1), (30, 1), (40, 1), (50, 1), (60, 1), (70, 1), (80, 1), (90, 1), (100, 1), (110, 1), (120, 0), (130, 0), (140, 0), (150, 0), (160, 0), (170, 0), (180, 0), (190, 0), (200, 1), (210, 1), (220, 1), (230, 1), (240, 1), (250, 1), (260, 1), (270, 1), (280, 1), (290, 1), (300, 1), (310, 1), (320, 0), (330, 0), (340, 0), (350, 0), (360, 0), (370, 0), (380, 0), (390, 0), (400, 0), (410, 1), (420, 1), (430, 1), (440, 1), (450, 1), (460, 1), (470, 1), (480, 1), (490, 1), (500, 1), (510, 1), (520, 1), (530, 1), (540, 0), (550, 1), (560, 1), (570, 1), (580, 1), (590, 0), (600, 0), (610, 0), (620, 0), (630, 1), (640, 1), (650, 1), (660, 1), (670, 0), (680, 0), (690, 0), (700, 0), (710, 0), (720, 0), (730, 1), (740, 1), (750, 1), (760, 0), (770, 1), (780, 1), (790, 1), (800, 1), (810, 1), (820, 1), (830, 1), (840, 0), (850, 0), (860, 0), (870, 0), (880, 0), (890, 0), (900, 0), (910, 0), (920, 1), (930, 1), (940, 1), (950, 1), (960, 1), (970, 1), (980, 1), (990, 1), (1000, 1), (1010, 1), (1020, 1), (1030, 1), (1040, 1), (1050, 1), (1060, 1), (1070, 1), (1080, 1), (1090, 1), (1100, 1), (1110, 1), (1120, 1), (1130, 1), (1140, 1), (1150, 1), (1160, 1), (1170, 1), (1180, 1), (1190, 1), (1200, 1), (1210, 1), (1220, 1), (1230, 1), (1240, 1), (1250, 0), (1260, 0), (1270, 1), (1280, 1), (1290, 1), (1300, 1), (1310, 1), (1320, 1), (1330, 1), (1340, 1), (1350, 1), (1360, 1), (1370, 1), (1380, 1), (1390, 1), (1400, 1), (1410, 1), (1420, 1), (1430, 1), (1440, 1), (1450, 1), (1460, 1), (1470, 1), (1480, 1), (1490, 1), (1500, 1), (1510, 1), (1520, 1), (1530, 1), (1540, 1), (1550, 0), (1560, 1), (1570, 1), (1580, 1), (1590, 1), (1600, 1), (1610, 1), (1620, 1), (1630, 1), (1640, 1), (1650, 1), (1660, 1), (1670, 1), (1680, 1), (1690, 1), (1700, 1), (1710, 1), (1720, 1), (1730, 1), (1740, 1), (1750, 1), (1760, 1), (1770, 1), (1780, 1), (1790, 1), (1800, 1), (1810, 1), (1820, 1), (1830, 1), (1840, 1), (1850, 1), (1860, 1), (1870, 1), (1880, 1), (1890, 1), (1900, 0), (1910, 1), (1920, 1), (1930, 0), (1940, 0), (1950, 0), (1960, 0), (1970, 0), (1980, 1), (1990, 1), (2000, 1), (2010, 1), (2020, 1), (2030, 1), (2040, 1), (2050, 1)]
VWMASK0_2  WMASK0_2  0 PWL (0n 0.0v 9.495n 0.0v 9.505n 1.8v 19.495n 1.8v 19.505n 1.8v 29.495n 1.8v 29.505n 1.8v 39.495n 1.8v 39.505n 1.8v 49.495n 1.8v 49.505n 1.8v 59.495n 1.8v 59.505n 1.8v 69.495n 1.8v 69.505n 1.8v 79.495n 1.8v 79.505n 1.8v 89.495n 1.8v 89.505n 1.8v 99.495n 1.8v 99.505n 1.8v 109.495n 1.8v 109.505n 1.8v 119.495n 1.8v 119.505n 0.0v 129.495n 0.0v 129.505n 0.0v 139.495n 0.0v 139.505n 0.0v 149.495n 0.0v 149.505n 0.0v 159.495n 0.0v 159.505n 0.0v 169.495n 0.0v 169.505n 0.0v 179.495n 0.0v 179.505n 0.0v 189.495n 0.0v 189.505n 0.0v 199.495n 0.0v 199.505n 1.8v 209.495n 1.8v 209.505n 1.8v 219.495n 1.8v 219.505n 1.8v 229.495n 1.8v 229.505n 1.8v 239.495n 1.8v 239.505n 1.8v 249.495n 1.8v 249.505n 1.8v 259.495n 1.8v 259.505n 1.8v 269.495n 1.8v 269.505n 1.8v 279.495n 1.8v 279.505n 1.8v 289.495n 1.8v 289.505n 1.8v 299.495n 1.8v 299.505n 1.8v 309.495n 1.8v 309.505n 1.8v 319.495n 1.8v 319.505n 0.0v 329.495n 0.0v 329.505n 0.0v 339.495n 0.0v 339.505n 0.0v 349.495n 0.0v 349.505n 0.0v 359.495n 0.0v 359.505n 0.0v 369.495n 0.0v 369.505n 0.0v 379.495n 0.0v 379.505n 0.0v 389.495n 0.0v 389.505n 0.0v 399.495n 0.0v 399.505n 0.0v 409.495n 0.0v 409.505n 1.8v 419.495n 1.8v 419.505n 1.8v 429.495n 1.8v 429.505n 1.8v 439.495n 1.8v 439.505n 1.8v 449.495n 1.8v 449.505n 1.8v 459.495n 1.8v 459.505n 1.8v 469.495n 1.8v 469.505n 1.8v 479.495n 1.8v 479.505n 1.8v 489.495n 1.8v 489.505n 1.8v 499.495n 1.8v 499.505n 1.8v 509.495n 1.8v 509.505n 1.8v 519.495n 1.8v 519.505n 1.8v 529.495n 1.8v 529.505n 1.8v 539.495n 1.8v 539.505n 0.0v 549.495n 0.0v 549.505n 1.8v 559.495n 1.8v 559.505n 1.8v 569.495n 1.8v 569.505n 1.8v 579.495n 1.8v 579.505n 1.8v 589.495n 1.8v 589.505n 0.0v 599.495n 0.0v 599.505n 0.0v 609.495n 0.0v 609.505n 0.0v 619.495n 0.0v 619.505n 0.0v 629.495n 0.0v 629.505n 1.8v 639.495n 1.8v 639.505n 1.8v 649.495n 1.8v 649.505n 1.8v 659.495n 1.8v 659.505n 1.8v 669.495n 1.8v 669.505n 0.0v 679.495n 0.0v 679.505n 0.0v 689.495n 0.0v 689.505n 0.0v 699.495n 0.0v 699.505n 0.0v 709.495n 0.0v 709.505n 0.0v 719.495n 0.0v 719.505n 0.0v 729.495n 0.0v 729.505n 1.8v 739.495n 1.8v 739.505n 1.8v 749.495n 1.8v 749.505n 1.8v 759.495n 1.8v 759.505n 0.0v 769.495n 0.0v 769.505n 1.8v 779.495n 1.8v 779.505n 1.8v 789.495n 1.8v 789.505n 1.8v 799.495n 1.8v 799.505n 1.8v 809.495n 1.8v 809.505n 1.8v 819.495n 1.8v 819.505n 1.8v 829.495n 1.8v 829.505n 1.8v 839.495n 1.8v 839.505n 0.0v 849.495n 0.0v 849.505n 0.0v 859.495n 0.0v 859.505n 0.0v 869.495n 0.0v 869.505n 0.0v 879.495n 0.0v 879.505n 0.0v 889.495n 0.0v 889.505n 0.0v 899.495n 0.0v 899.505n 0.0v 909.495n 0.0v 909.505n 0.0v 919.495n 0.0v 919.505n 1.8v 929.495n 1.8v 929.505n 1.8v 939.495n 1.8v 939.505n 1.8v 949.495n 1.8v 949.505n 1.8v 959.495n 1.8v 959.505n 1.8v 969.495n 1.8v 969.505n 1.8v 979.495n 1.8v 979.505n 1.8v 989.495n 1.8v 989.505n 1.8v 999.495n 1.8v 999.505n 1.8v 1009.495n 1.8v 1009.505n 1.8v 1019.495n 1.8v 1019.505n 1.8v 1029.495n 1.8v 1029.505n 1.8v 1039.495n 1.8v 1039.505n 1.8v 1049.495n 1.8v 1049.505n 1.8v 1059.495n 1.8v 1059.505n 1.8v 1069.495n 1.8v 1069.505n 1.8v 1079.495n 1.8v 1079.505n 1.8v 1089.495n 1.8v 1089.505n 1.8v 1099.495n 1.8v 1099.505n 1.8v 1109.495n 1.8v 1109.505n 1.8v 1119.495n 1.8v 1119.505n 1.8v 1129.495n 1.8v 1129.505n 1.8v 1139.495n 1.8v 1139.505n 1.8v 1149.495n 1.8v 1149.505n 1.8v 1159.495n 1.8v 1159.505n 1.8v 1169.495n 1.8v 1169.505n 1.8v 1179.495n 1.8v 1179.505n 1.8v 1189.495n 1.8v 1189.505n 1.8v 1199.495n 1.8v 1199.505n 1.8v 1209.495n 1.8v 1209.505n 1.8v 1219.495n 1.8v 1219.505n 1.8v 1229.495n 1.8v 1229.505n 1.8v 1239.495n 1.8v 1239.505n 1.8v 1249.495n 1.8v 1249.505n 0.0v 1259.495n 0.0v 1259.505n 0.0v 1269.495n 0.0v 1269.505n 1.8v 1279.495n 1.8v 1279.505n 1.8v 1289.495n 1.8v 1289.505n 1.8v 1299.495n 1.8v 1299.505n 1.8v 1309.495n 1.8v 1309.505n 1.8v 1319.495n 1.8v 1319.505n 1.8v 1329.495n 1.8v 1329.505n 1.8v 1339.495n 1.8v 1339.505n 1.8v 1349.495n 1.8v 1349.505n 1.8v 1359.495n 1.8v 1359.505n 1.8v 1369.495n 1.8v 1369.505n 1.8v 1379.495n 1.8v 1379.505n 1.8v 1389.495n 1.8v 1389.505n 1.8v 1399.495n 1.8v 1399.505n 1.8v 1409.495n 1.8v 1409.505n 1.8v 1419.495n 1.8v 1419.505n 1.8v 1429.495n 1.8v 1429.505n 1.8v 1439.495n 1.8v 1439.505n 1.8v 1449.495n 1.8v 1449.505n 1.8v 1459.495n 1.8v 1459.505n 1.8v 1469.495n 1.8v 1469.505n 1.8v 1479.495n 1.8v 1479.505n 1.8v 1489.495n 1.8v 1489.505n 1.8v 1499.495n 1.8v 1499.505n 1.8v 1509.495n 1.8v 1509.505n 1.8v 1519.495n 1.8v 1519.505n 1.8v 1529.495n 1.8v 1529.505n 1.8v 1539.495n 1.8v 1539.505n 1.8v 1549.495n 1.8v 1549.505n 0.0v 1559.495n 0.0v 1559.505n 1.8v 1569.495n 1.8v 1569.505n 1.8v 1579.495n 1.8v 1579.505n 1.8v 1589.495n 1.8v 1589.505n 1.8v 1599.495n 1.8v 1599.505n 1.8v 1609.495n 1.8v 1609.505n 1.8v 1619.495n 1.8v 1619.505n 1.8v 1629.495n 1.8v 1629.505n 1.8v 1639.495n 1.8v 1639.505n 1.8v 1649.495n 1.8v 1649.505n 1.8v 1659.495n 1.8v 1659.505n 1.8v 1669.495n 1.8v 1669.505n 1.8v 1679.495n 1.8v 1679.505n 1.8v 1689.495n 1.8v 1689.505n 1.8v 1699.495n 1.8v 1699.505n 1.8v 1709.495n 1.8v 1709.505n 1.8v 1719.495n 1.8v 1719.505n 1.8v 1729.495n 1.8v 1729.505n 1.8v 1739.495n 1.8v 1739.505n 1.8v 1749.495n 1.8v 1749.505n 1.8v 1759.495n 1.8v 1759.505n 1.8v 1769.495n 1.8v 1769.505n 1.8v 1779.495n 1.8v 1779.505n 1.8v 1789.495n 1.8v 1789.505n 1.8v 1799.495n 1.8v 1799.505n 1.8v 1809.495n 1.8v 1809.505n 1.8v 1819.495n 1.8v 1819.505n 1.8v 1829.495n 1.8v 1829.505n 1.8v 1839.495n 1.8v 1839.505n 1.8v 1849.495n 1.8v 1849.505n 1.8v 1859.495n 1.8v 1859.505n 1.8v 1869.495n 1.8v 1869.505n 1.8v 1879.495n 1.8v 1879.505n 1.8v 1889.495n 1.8v 1889.505n 1.8v 1899.495n 1.8v 1899.505n 0.0v 1909.495n 0.0v 1909.505n 1.8v 1919.495n 1.8v 1919.505n 1.8v 1929.495n 1.8v 1929.505n 0.0v 1939.495n 0.0v 1939.505n 0.0v 1949.495n 0.0v 1949.505n 0.0v 1959.495n 0.0v 1959.505n 0.0v 1969.495n 0.0v 1969.505n 0.0v 1979.495n 0.0v 1979.505n 1.8v 1989.495n 1.8v 1989.505n 1.8v 1999.495n 1.8v 1999.505n 1.8v 2009.495n 1.8v 2009.505n 1.8v 2019.495n 1.8v 2019.505n 1.8v 2029.495n 1.8v 2029.505n 1.8v 2039.495n 1.8v 2039.505n 1.8v 2049.495n 1.8v 2049.505n 1.8v )
* (time, data): [(0, 0), (10, 1), (20, 1), (30, 1), (40, 1), (50, 1), (60, 1), (70, 1), (80, 1), (90, 1), (100, 1), (110, 1), (120, 1), (130, 1), (140, 1), (150, 1), (160, 1), (170, 1), (180, 1), (190, 1), (200, 1), (210, 1), (220, 1), (230, 1), (240, 1), (250, 0), (260, 0), (270, 0), (280, 0), (290, 0), (300, 0), (310, 0), (320, 0), (330, 0), (340, 0), (350, 0), (360, 1), (370, 1), (380, 1), (390, 1), (400, 1), (410, 0), (420, 1), (430, 1), (440, 0), (450, 0), (460, 0), (470, 0), (480, 0), (490, 0), (500, 0), (510, 1), (520, 1), (530, 1), (540, 1), (550, 1), (560, 1), (570, 1), (580, 0), (590, 1), (600, 1), (610, 1), (620, 1), (630, 1), (640, 1), (650, 1), (660, 1), (670, 1), (680, 1), (690, 1), (700, 1), (710, 1), (720, 1), (730, 1), (740, 0), (750, 0), (760, 0), (770, 0), (780, 1), (790, 1), (800, 1), (810, 1), (820, 1), (830, 1), (840, 0), (850, 0), (860, 0), (870, 1), (880, 1), (890, 1), (900, 1), (910, 1), (920, 1), (930, 1), (940, 1), (950, 1), (960, 1), (970, 1), (980, 1), (990, 1), (1000, 1), (1010, 1), (1020, 1), (1030, 1), (1040, 1), (1050, 1), (1060, 1), (1070, 1), (1080, 1), (1090, 1), (1100, 1), (1110, 1), (1120, 1), (1130, 1), (1140, 1), (1150, 1), (1160, 1), (1170, 1), (1180, 1), (1190, 1), (1200, 1), (1210, 1), (1220, 1), (1230, 1), (1240, 1), (1250, 1), (1260, 0), (1270, 0), (1280, 0), (1290, 0), (1300, 0), (1310, 0), (1320, 1), (1330, 1), (1340, 1), (1350, 1), (1360, 1), (1370, 1), (1380, 1), (1390, 1), (1400, 1), (1410, 1), (1420, 1), (1430, 1), (1440, 1), (1450, 1), (1460, 1), (1470, 0), (1480, 0), (1490, 0), (1500, 0), (1510, 0), (1520, 0), (1530, 0), (1540, 0), (1550, 0), (1560, 1), (1570, 1), (1580, 1), (1590, 1), (1600, 1), (1610, 1), (1620, 1), (1630, 1), (1640, 0), (1650, 0), (1660, 0), (1670, 0), (1680, 0), (1690, 0), (1700, 0), (1710, 0), (1720, 1), (1730, 1), (1740, 1), (1750, 1), (1760, 1), (1770, 1), (1780, 1), (1790, 1), (1800, 1), (1810, 0), (1820, 0), (1830, 0), (1840, 0), (1850, 0), (1860, 0), (1870, 0), (1880, 1), (1890, 1), (1900, 0), (1910, 0), (1920, 0), (1930, 1), (1940, 1), (1950, 1), (1960, 1), (1970, 1), (1980, 1), (1990, 1), (2000, 1), (2010, 1), (2020, 1), (2030, 1), (2040, 1), (2050, 1)]
VWMASK0_3  WMASK0_3  0 PWL (0n 0.0v 9.495n 0.0v 9.505n 1.8v 19.495n 1.8v 19.505n 1.8v 29.495n 1.8v 29.505n 1.8v 39.495n 1.8v 39.505n 1.8v 49.495n 1.8v 49.505n 1.8v 59.495n 1.8v 59.505n 1.8v 69.495n 1.8v 69.505n 1.8v 79.495n 1.8v 79.505n 1.8v 89.495n 1.8v 89.505n 1.8v 99.495n 1.8v 99.505n 1.8v 109.495n 1.8v 109.505n 1.8v 119.495n 1.8v 119.505n 1.8v 129.495n 1.8v 129.505n 1.8v 139.495n 1.8v 139.505n 1.8v 149.495n 1.8v 149.505n 1.8v 159.495n 1.8v 159.505n 1.8v 169.495n 1.8v 169.505n 1.8v 179.495n 1.8v 179.505n 1.8v 189.495n 1.8v 189.505n 1.8v 199.495n 1.8v 199.505n 1.8v 209.495n 1.8v 209.505n 1.8v 219.495n 1.8v 219.505n 1.8v 229.495n 1.8v 229.505n 1.8v 239.495n 1.8v 239.505n 1.8v 249.495n 1.8v 249.505n 0.0v 259.495n 0.0v 259.505n 0.0v 269.495n 0.0v 269.505n 0.0v 279.495n 0.0v 279.505n 0.0v 289.495n 0.0v 289.505n 0.0v 299.495n 0.0v 299.505n 0.0v 309.495n 0.0v 309.505n 0.0v 319.495n 0.0v 319.505n 0.0v 329.495n 0.0v 329.505n 0.0v 339.495n 0.0v 339.505n 0.0v 349.495n 0.0v 349.505n 0.0v 359.495n 0.0v 359.505n 1.8v 369.495n 1.8v 369.505n 1.8v 379.495n 1.8v 379.505n 1.8v 389.495n 1.8v 389.505n 1.8v 399.495n 1.8v 399.505n 1.8v 409.495n 1.8v 409.505n 0.0v 419.495n 0.0v 419.505n 1.8v 429.495n 1.8v 429.505n 1.8v 439.495n 1.8v 439.505n 0.0v 449.495n 0.0v 449.505n 0.0v 459.495n 0.0v 459.505n 0.0v 469.495n 0.0v 469.505n 0.0v 479.495n 0.0v 479.505n 0.0v 489.495n 0.0v 489.505n 0.0v 499.495n 0.0v 499.505n 0.0v 509.495n 0.0v 509.505n 1.8v 519.495n 1.8v 519.505n 1.8v 529.495n 1.8v 529.505n 1.8v 539.495n 1.8v 539.505n 1.8v 549.495n 1.8v 549.505n 1.8v 559.495n 1.8v 559.505n 1.8v 569.495n 1.8v 569.505n 1.8v 579.495n 1.8v 579.505n 0.0v 589.495n 0.0v 589.505n 1.8v 599.495n 1.8v 599.505n 1.8v 609.495n 1.8v 609.505n 1.8v 619.495n 1.8v 619.505n 1.8v 629.495n 1.8v 629.505n 1.8v 639.495n 1.8v 639.505n 1.8v 649.495n 1.8v 649.505n 1.8v 659.495n 1.8v 659.505n 1.8v 669.495n 1.8v 669.505n 1.8v 679.495n 1.8v 679.505n 1.8v 689.495n 1.8v 689.505n 1.8v 699.495n 1.8v 699.505n 1.8v 709.495n 1.8v 709.505n 1.8v 719.495n 1.8v 719.505n 1.8v 729.495n 1.8v 729.505n 1.8v 739.495n 1.8v 739.505n 0.0v 749.495n 0.0v 749.505n 0.0v 759.495n 0.0v 759.505n 0.0v 769.495n 0.0v 769.505n 0.0v 779.495n 0.0v 779.505n 1.8v 789.495n 1.8v 789.505n 1.8v 799.495n 1.8v 799.505n 1.8v 809.495n 1.8v 809.505n 1.8v 819.495n 1.8v 819.505n 1.8v 829.495n 1.8v 829.505n 1.8v 839.495n 1.8v 839.505n 0.0v 849.495n 0.0v 849.505n 0.0v 859.495n 0.0v 859.505n 0.0v 869.495n 0.0v 869.505n 1.8v 879.495n 1.8v 879.505n 1.8v 889.495n 1.8v 889.505n 1.8v 899.495n 1.8v 899.505n 1.8v 909.495n 1.8v 909.505n 1.8v 919.495n 1.8v 919.505n 1.8v 929.495n 1.8v 929.505n 1.8v 939.495n 1.8v 939.505n 1.8v 949.495n 1.8v 949.505n 1.8v 959.495n 1.8v 959.505n 1.8v 969.495n 1.8v 969.505n 1.8v 979.495n 1.8v 979.505n 1.8v 989.495n 1.8v 989.505n 1.8v 999.495n 1.8v 999.505n 1.8v 1009.495n 1.8v 1009.505n 1.8v 1019.495n 1.8v 1019.505n 1.8v 1029.495n 1.8v 1029.505n 1.8v 1039.495n 1.8v 1039.505n 1.8v 1049.495n 1.8v 1049.505n 1.8v 1059.495n 1.8v 1059.505n 1.8v 1069.495n 1.8v 1069.505n 1.8v 1079.495n 1.8v 1079.505n 1.8v 1089.495n 1.8v 1089.505n 1.8v 1099.495n 1.8v 1099.505n 1.8v 1109.495n 1.8v 1109.505n 1.8v 1119.495n 1.8v 1119.505n 1.8v 1129.495n 1.8v 1129.505n 1.8v 1139.495n 1.8v 1139.505n 1.8v 1149.495n 1.8v 1149.505n 1.8v 1159.495n 1.8v 1159.505n 1.8v 1169.495n 1.8v 1169.505n 1.8v 1179.495n 1.8v 1179.505n 1.8v 1189.495n 1.8v 1189.505n 1.8v 1199.495n 1.8v 1199.505n 1.8v 1209.495n 1.8v 1209.505n 1.8v 1219.495n 1.8v 1219.505n 1.8v 1229.495n 1.8v 1229.505n 1.8v 1239.495n 1.8v 1239.505n 1.8v 1249.495n 1.8v 1249.505n 1.8v 1259.495n 1.8v 1259.505n 0.0v 1269.495n 0.0v 1269.505n 0.0v 1279.495n 0.0v 1279.505n 0.0v 1289.495n 0.0v 1289.505n 0.0v 1299.495n 0.0v 1299.505n 0.0v 1309.495n 0.0v 1309.505n 0.0v 1319.495n 0.0v 1319.505n 1.8v 1329.495n 1.8v 1329.505n 1.8v 1339.495n 1.8v 1339.505n 1.8v 1349.495n 1.8v 1349.505n 1.8v 1359.495n 1.8v 1359.505n 1.8v 1369.495n 1.8v 1369.505n 1.8v 1379.495n 1.8v 1379.505n 1.8v 1389.495n 1.8v 1389.505n 1.8v 1399.495n 1.8v 1399.505n 1.8v 1409.495n 1.8v 1409.505n 1.8v 1419.495n 1.8v 1419.505n 1.8v 1429.495n 1.8v 1429.505n 1.8v 1439.495n 1.8v 1439.505n 1.8v 1449.495n 1.8v 1449.505n 1.8v 1459.495n 1.8v 1459.505n 1.8v 1469.495n 1.8v 1469.505n 0.0v 1479.495n 0.0v 1479.505n 0.0v 1489.495n 0.0v 1489.505n 0.0v 1499.495n 0.0v 1499.505n 0.0v 1509.495n 0.0v 1509.505n 0.0v 1519.495n 0.0v 1519.505n 0.0v 1529.495n 0.0v 1529.505n 0.0v 1539.495n 0.0v 1539.505n 0.0v 1549.495n 0.0v 1549.505n 0.0v 1559.495n 0.0v 1559.505n 1.8v 1569.495n 1.8v 1569.505n 1.8v 1579.495n 1.8v 1579.505n 1.8v 1589.495n 1.8v 1589.505n 1.8v 1599.495n 1.8v 1599.505n 1.8v 1609.495n 1.8v 1609.505n 1.8v 1619.495n 1.8v 1619.505n 1.8v 1629.495n 1.8v 1629.505n 1.8v 1639.495n 1.8v 1639.505n 0.0v 1649.495n 0.0v 1649.505n 0.0v 1659.495n 0.0v 1659.505n 0.0v 1669.495n 0.0v 1669.505n 0.0v 1679.495n 0.0v 1679.505n 0.0v 1689.495n 0.0v 1689.505n 0.0v 1699.495n 0.0v 1699.505n 0.0v 1709.495n 0.0v 1709.505n 0.0v 1719.495n 0.0v 1719.505n 1.8v 1729.495n 1.8v 1729.505n 1.8v 1739.495n 1.8v 1739.505n 1.8v 1749.495n 1.8v 1749.505n 1.8v 1759.495n 1.8v 1759.505n 1.8v 1769.495n 1.8v 1769.505n 1.8v 1779.495n 1.8v 1779.505n 1.8v 1789.495n 1.8v 1789.505n 1.8v 1799.495n 1.8v 1799.505n 1.8v 1809.495n 1.8v 1809.505n 0.0v 1819.495n 0.0v 1819.505n 0.0v 1829.495n 0.0v 1829.505n 0.0v 1839.495n 0.0v 1839.505n 0.0v 1849.495n 0.0v 1849.505n 0.0v 1859.495n 0.0v 1859.505n 0.0v 1869.495n 0.0v 1869.505n 0.0v 1879.495n 0.0v 1879.505n 1.8v 1889.495n 1.8v 1889.505n 1.8v 1899.495n 1.8v 1899.505n 0.0v 1909.495n 0.0v 1909.505n 0.0v 1919.495n 0.0v 1919.505n 0.0v 1929.495n 0.0v 1929.505n 1.8v 1939.495n 1.8v 1939.505n 1.8v 1949.495n 1.8v 1949.505n 1.8v 1959.495n 1.8v 1959.505n 1.8v 1969.495n 1.8v 1969.505n 1.8v 1979.495n 1.8v 1979.505n 1.8v 1989.495n 1.8v 1989.505n 1.8v 1999.495n 1.8v 1999.505n 1.8v 2009.495n 1.8v 2009.505n 1.8v 2019.495n 1.8v 2019.505n 1.8v 2029.495n 1.8v 2029.505n 1.8v 2039.495n 1.8v 2039.505n 1.8v 2049.495n 1.8v 2049.505n 1.8v )
* PULSE: period=10
Vclk0 clk0 0 PULSE (0 1.8 9.995n 0.01n 0.01n 4.99n 10n)
* PULSE: period=10
Vclk1 clk1 0 PULSE (0 1.8 9.995n 0.01n 0.01n 4.99n 10n)

 * Generation of dout measurements
* CHECK dout0_0 vdout0_0ck4 = 0 time = 50
* CHECK dout0_1 vdout0_1ck4 = 1.8 time = 50
* CHECK dout0_2 vdout0_2ck4 = 0 time = 50
* CHECK dout0_3 vdout0_3ck4 = 1.8 time = 50
* CHECK dout0_4 vdout0_4ck4 = 0 time = 50
* CHECK dout0_5 vdout0_5ck4 = 1.8 time = 50
* CHECK dout0_6 vdout0_6ck4 = 0 time = 50
* CHECK dout0_7 vdout0_7ck4 = 1.8 time = 50
* CHECK dout0_8 vdout0_8ck4 = 0 time = 50
* CHECK dout0_9 vdout0_9ck4 = 1.8 time = 50
* CHECK dout0_10 vdout0_10ck4 = 0 time = 50
* CHECK dout0_11 vdout0_11ck4 = 0 time = 50
* CHECK dout0_12 vdout0_12ck4 = 1.8 time = 50
* CHECK dout0_13 vdout0_13ck4 = 1.8 time = 50
* CHECK dout0_14 vdout0_14ck4 = 0 time = 50
* CHECK dout0_15 vdout0_15ck4 = 1.8 time = 50
* CHECK dout0_16 vdout0_16ck4 = 0 time = 50
* CHECK dout0_17 vdout0_17ck4 = 1.8 time = 50
* CHECK dout0_18 vdout0_18ck4 = 1.8 time = 50
* CHECK dout0_19 vdout0_19ck4 = 0 time = 50
* CHECK dout0_20 vdout0_20ck4 = 0 time = 50
* CHECK dout0_21 vdout0_21ck4 = 0 time = 50
* CHECK dout0_22 vdout0_22ck4 = 1.8 time = 50
* CHECK dout0_23 vdout0_23ck4 = 1.8 time = 50
* CHECK dout0_24 vdout0_24ck4 = 0 time = 50
* CHECK dout0_25 vdout0_25ck4 = 1.8 time = 50
* CHECK dout0_26 vdout0_26ck4 = 1.8 time = 50
* CHECK dout0_27 vdout0_27ck4 = 1.8 time = 50
* CHECK dout0_28 vdout0_28ck4 = 0 time = 50
* CHECK dout0_29 vdout0_29ck4 = 1.8 time = 50
* CHECK dout0_30 vdout0_30ck4 = 0 time = 50
* CHECK dout0_31 vdout0_31ck4 = 0 time = 50
* CHECK dout1_0 vdout1_0ck4 = 0 time = 50
* CHECK dout1_1 vdout1_1ck4 = 1.8 time = 50
* CHECK dout1_2 vdout1_2ck4 = 1.8 time = 50
* CHECK dout1_3 vdout1_3ck4 = 1.8 time = 50
* CHECK dout1_4 vdout1_4ck4 = 0 time = 50
* CHECK dout1_5 vdout1_5ck4 = 1.8 time = 50
* CHECK dout1_6 vdout1_6ck4 = 0 time = 50
* CHECK dout1_7 vdout1_7ck4 = 0 time = 50
* CHECK dout1_8 vdout1_8ck4 = 0 time = 50
* CHECK dout1_9 vdout1_9ck4 = 1.8 time = 50
* CHECK dout1_10 vdout1_10ck4 = 0 time = 50
* CHECK dout1_11 vdout1_11ck4 = 0 time = 50
* CHECK dout1_12 vdout1_12ck4 = 1.8 time = 50
* CHECK dout1_13 vdout1_13ck4 = 1.8 time = 50
* CHECK dout1_14 vdout1_14ck4 = 1.8 time = 50
* CHECK dout1_15 vdout1_15ck4 = 0 time = 50
* CHECK dout1_16 vdout1_16ck4 = 1.8 time = 50
* CHECK dout1_17 vdout1_17ck4 = 0 time = 50
* CHECK dout1_18 vdout1_18ck4 = 1.8 time = 50
* CHECK dout1_19 vdout1_19ck4 = 1.8 time = 50
* CHECK dout1_20 vdout1_20ck4 = 1.8 time = 50
* CHECK dout1_21 vdout1_21ck4 = 0 time = 50
* CHECK dout1_22 vdout1_22ck4 = 1.8 time = 50
* CHECK dout1_23 vdout1_23ck4 = 0 time = 50
* CHECK dout1_24 vdout1_24ck4 = 1.8 time = 50
* CHECK dout1_25 vdout1_25ck4 = 0 time = 50
* CHECK dout1_26 vdout1_26ck4 = 0 time = 50
* CHECK dout1_27 vdout1_27ck4 = 0 time = 50
* CHECK dout1_28 vdout1_28ck4 = 0 time = 50
* CHECK dout1_29 vdout1_29ck4 = 0 time = 50
* CHECK dout1_30 vdout1_30ck4 = 0 time = 50
* CHECK dout1_31 vdout1_31ck4 = 0 time = 50
* CHECK dout0_0 vdout0_0ck5 = 0 time = 60
* CHECK dout0_1 vdout0_1ck5 = 1.8 time = 60
* CHECK dout0_2 vdout0_2ck5 = 1.8 time = 60
* CHECK dout0_3 vdout0_3ck5 = 1.8 time = 60
* CHECK dout0_4 vdout0_4ck5 = 0 time = 60
* CHECK dout0_5 vdout0_5ck5 = 1.8 time = 60
* CHECK dout0_6 vdout0_6ck5 = 0 time = 60
* CHECK dout0_7 vdout0_7ck5 = 0 time = 60
* CHECK dout0_8 vdout0_8ck5 = 0 time = 60
* CHECK dout0_9 vdout0_9ck5 = 1.8 time = 60
* CHECK dout0_10 vdout0_10ck5 = 0 time = 60
* CHECK dout0_11 vdout0_11ck5 = 0 time = 60
* CHECK dout0_12 vdout0_12ck5 = 1.8 time = 60
* CHECK dout0_13 vdout0_13ck5 = 1.8 time = 60
* CHECK dout0_14 vdout0_14ck5 = 1.8 time = 60
* CHECK dout0_15 vdout0_15ck5 = 0 time = 60
* CHECK dout0_16 vdout0_16ck5 = 1.8 time = 60
* CHECK dout0_17 vdout0_17ck5 = 0 time = 60
* CHECK dout0_18 vdout0_18ck5 = 1.8 time = 60
* CHECK dout0_19 vdout0_19ck5 = 1.8 time = 60
* CHECK dout0_20 vdout0_20ck5 = 1.8 time = 60
* CHECK dout0_21 vdout0_21ck5 = 0 time = 60
* CHECK dout0_22 vdout0_22ck5 = 1.8 time = 60
* CHECK dout0_23 vdout0_23ck5 = 0 time = 60
* CHECK dout0_24 vdout0_24ck5 = 1.8 time = 60
* CHECK dout0_25 vdout0_25ck5 = 0 time = 60
* CHECK dout0_26 vdout0_26ck5 = 0 time = 60
* CHECK dout0_27 vdout0_27ck5 = 0 time = 60
* CHECK dout0_28 vdout0_28ck5 = 0 time = 60
* CHECK dout0_29 vdout0_29ck5 = 0 time = 60
* CHECK dout0_30 vdout0_30ck5 = 0 time = 60
* CHECK dout0_31 vdout0_31ck5 = 0 time = 60
* CHECK dout0_0 vdout0_0ck7 = 0 time = 80
* CHECK dout0_1 vdout0_1ck7 = 1.8 time = 80
* CHECK dout0_2 vdout0_2ck7 = 0 time = 80
* CHECK dout0_3 vdout0_3ck7 = 1.8 time = 80
* CHECK dout0_4 vdout0_4ck7 = 0 time = 80
* CHECK dout0_5 vdout0_5ck7 = 1.8 time = 80
* CHECK dout0_6 vdout0_6ck7 = 0 time = 80
* CHECK dout0_7 vdout0_7ck7 = 1.8 time = 80
* CHECK dout0_8 vdout0_8ck7 = 0 time = 80
* CHECK dout0_9 vdout0_9ck7 = 1.8 time = 80
* CHECK dout0_10 vdout0_10ck7 = 0 time = 80
* CHECK dout0_11 vdout0_11ck7 = 0 time = 80
* CHECK dout0_12 vdout0_12ck7 = 1.8 time = 80
* CHECK dout0_13 vdout0_13ck7 = 1.8 time = 80
* CHECK dout0_14 vdout0_14ck7 = 0 time = 80
* CHECK dout0_15 vdout0_15ck7 = 1.8 time = 80
* CHECK dout0_16 vdout0_16ck7 = 0 time = 80
* CHECK dout0_17 vdout0_17ck7 = 1.8 time = 80
* CHECK dout0_18 vdout0_18ck7 = 1.8 time = 80
* CHECK dout0_19 vdout0_19ck7 = 0 time = 80
* CHECK dout0_20 vdout0_20ck7 = 0 time = 80
* CHECK dout0_21 vdout0_21ck7 = 0 time = 80
* CHECK dout0_22 vdout0_22ck7 = 1.8 time = 80
* CHECK dout0_23 vdout0_23ck7 = 1.8 time = 80
* CHECK dout0_24 vdout0_24ck7 = 0 time = 80
* CHECK dout0_25 vdout0_25ck7 = 1.8 time = 80
* CHECK dout0_26 vdout0_26ck7 = 1.8 time = 80
* CHECK dout0_27 vdout0_27ck7 = 1.8 time = 80
* CHECK dout0_28 vdout0_28ck7 = 0 time = 80
* CHECK dout0_29 vdout0_29ck7 = 1.8 time = 80
* CHECK dout0_30 vdout0_30ck7 = 0 time = 80
* CHECK dout0_31 vdout0_31ck7 = 0 time = 80
* CHECK dout1_0 vdout1_0ck7 = 0 time = 80
* CHECK dout1_1 vdout1_1ck7 = 1.8 time = 80
* CHECK dout1_2 vdout1_2ck7 = 1.8 time = 80
* CHECK dout1_3 vdout1_3ck7 = 1.8 time = 80
* CHECK dout1_4 vdout1_4ck7 = 0 time = 80
* CHECK dout1_5 vdout1_5ck7 = 1.8 time = 80
* CHECK dout1_6 vdout1_6ck7 = 0 time = 80
* CHECK dout1_7 vdout1_7ck7 = 0 time = 80
* CHECK dout1_8 vdout1_8ck7 = 0 time = 80
* CHECK dout1_9 vdout1_9ck7 = 1.8 time = 80
* CHECK dout1_10 vdout1_10ck7 = 0 time = 80
* CHECK dout1_11 vdout1_11ck7 = 0 time = 80
* CHECK dout1_12 vdout1_12ck7 = 1.8 time = 80
* CHECK dout1_13 vdout1_13ck7 = 1.8 time = 80
* CHECK dout1_14 vdout1_14ck7 = 1.8 time = 80
* CHECK dout1_15 vdout1_15ck7 = 0 time = 80
* CHECK dout1_16 vdout1_16ck7 = 1.8 time = 80
* CHECK dout1_17 vdout1_17ck7 = 0 time = 80
* CHECK dout1_18 vdout1_18ck7 = 1.8 time = 80
* CHECK dout1_19 vdout1_19ck7 = 1.8 time = 80
* CHECK dout1_20 vdout1_20ck7 = 1.8 time = 80
* CHECK dout1_21 vdout1_21ck7 = 0 time = 80
* CHECK dout1_22 vdout1_22ck7 = 1.8 time = 80
* CHECK dout1_23 vdout1_23ck7 = 0 time = 80
* CHECK dout1_24 vdout1_24ck7 = 1.8 time = 80
* CHECK dout1_25 vdout1_25ck7 = 0 time = 80
* CHECK dout1_26 vdout1_26ck7 = 0 time = 80
* CHECK dout1_27 vdout1_27ck7 = 0 time = 80
* CHECK dout1_28 vdout1_28ck7 = 0 time = 80
* CHECK dout1_29 vdout1_29ck7 = 0 time = 80
* CHECK dout1_30 vdout1_30ck7 = 0 time = 80
* CHECK dout1_31 vdout1_31ck7 = 0 time = 80
* CHECK dout0_0 vdout0_0ck8 = 0 time = 90
* CHECK dout0_1 vdout0_1ck8 = 1.8 time = 90
* CHECK dout0_2 vdout0_2ck8 = 1.8 time = 90
* CHECK dout0_3 vdout0_3ck8 = 1.8 time = 90
* CHECK dout0_4 vdout0_4ck8 = 0 time = 90
* CHECK dout0_5 vdout0_5ck8 = 1.8 time = 90
* CHECK dout0_6 vdout0_6ck8 = 0 time = 90
* CHECK dout0_7 vdout0_7ck8 = 0 time = 90
* CHECK dout0_8 vdout0_8ck8 = 0 time = 90
* CHECK dout0_9 vdout0_9ck8 = 1.8 time = 90
* CHECK dout0_10 vdout0_10ck8 = 0 time = 90
* CHECK dout0_11 vdout0_11ck8 = 0 time = 90
* CHECK dout0_12 vdout0_12ck8 = 1.8 time = 90
* CHECK dout0_13 vdout0_13ck8 = 1.8 time = 90
* CHECK dout0_14 vdout0_14ck8 = 1.8 time = 90
* CHECK dout0_15 vdout0_15ck8 = 0 time = 90
* CHECK dout0_16 vdout0_16ck8 = 1.8 time = 90
* CHECK dout0_17 vdout0_17ck8 = 0 time = 90
* CHECK dout0_18 vdout0_18ck8 = 1.8 time = 90
* CHECK dout0_19 vdout0_19ck8 = 1.8 time = 90
* CHECK dout0_20 vdout0_20ck8 = 1.8 time = 90
* CHECK dout0_21 vdout0_21ck8 = 0 time = 90
* CHECK dout0_22 vdout0_22ck8 = 1.8 time = 90
* CHECK dout0_23 vdout0_23ck8 = 0 time = 90
* CHECK dout0_24 vdout0_24ck8 = 1.8 time = 90
* CHECK dout0_25 vdout0_25ck8 = 0 time = 90
* CHECK dout0_26 vdout0_26ck8 = 0 time = 90
* CHECK dout0_27 vdout0_27ck8 = 0 time = 90
* CHECK dout0_28 vdout0_28ck8 = 0 time = 90
* CHECK dout0_29 vdout0_29ck8 = 0 time = 90
* CHECK dout0_30 vdout0_30ck8 = 0 time = 90
* CHECK dout0_31 vdout0_31ck8 = 0 time = 90
* CHECK dout0_0 vdout0_0ck10 = 0 time = 110
* CHECK dout0_1 vdout0_1ck10 = 1.8 time = 110
* CHECK dout0_2 vdout0_2ck10 = 1.8 time = 110
* CHECK dout0_3 vdout0_3ck10 = 1.8 time = 110
* CHECK dout0_4 vdout0_4ck10 = 0 time = 110
* CHECK dout0_5 vdout0_5ck10 = 1.8 time = 110
* CHECK dout0_6 vdout0_6ck10 = 0 time = 110
* CHECK dout0_7 vdout0_7ck10 = 0 time = 110
* CHECK dout0_8 vdout0_8ck10 = 0 time = 110
* CHECK dout0_9 vdout0_9ck10 = 1.8 time = 110
* CHECK dout0_10 vdout0_10ck10 = 0 time = 110
* CHECK dout0_11 vdout0_11ck10 = 0 time = 110
* CHECK dout0_12 vdout0_12ck10 = 1.8 time = 110
* CHECK dout0_13 vdout0_13ck10 = 1.8 time = 110
* CHECK dout0_14 vdout0_14ck10 = 1.8 time = 110
* CHECK dout0_15 vdout0_15ck10 = 0 time = 110
* CHECK dout0_16 vdout0_16ck10 = 1.8 time = 110
* CHECK dout0_17 vdout0_17ck10 = 0 time = 110
* CHECK dout0_18 vdout0_18ck10 = 1.8 time = 110
* CHECK dout0_19 vdout0_19ck10 = 1.8 time = 110
* CHECK dout0_20 vdout0_20ck10 = 1.8 time = 110
* CHECK dout0_21 vdout0_21ck10 = 0 time = 110
* CHECK dout0_22 vdout0_22ck10 = 1.8 time = 110
* CHECK dout0_23 vdout0_23ck10 = 0 time = 110
* CHECK dout0_24 vdout0_24ck10 = 1.8 time = 110
* CHECK dout0_25 vdout0_25ck10 = 0 time = 110
* CHECK dout0_26 vdout0_26ck10 = 0 time = 110
* CHECK dout0_27 vdout0_27ck10 = 0 time = 110
* CHECK dout0_28 vdout0_28ck10 = 0 time = 110
* CHECK dout0_29 vdout0_29ck10 = 0 time = 110
* CHECK dout0_30 vdout0_30ck10 = 0 time = 110
* CHECK dout0_31 vdout0_31ck10 = 0 time = 110
* CHECK dout1_0 vdout1_0ck10 = 0 time = 110
* CHECK dout1_1 vdout1_1ck10 = 1.8 time = 110
* CHECK dout1_2 vdout1_2ck10 = 0 time = 110
* CHECK dout1_3 vdout1_3ck10 = 1.8 time = 110
* CHECK dout1_4 vdout1_4ck10 = 0 time = 110
* CHECK dout1_5 vdout1_5ck10 = 1.8 time = 110
* CHECK dout1_6 vdout1_6ck10 = 0 time = 110
* CHECK dout1_7 vdout1_7ck10 = 1.8 time = 110
* CHECK dout1_8 vdout1_8ck10 = 0 time = 110
* CHECK dout1_9 vdout1_9ck10 = 1.8 time = 110
* CHECK dout1_10 vdout1_10ck10 = 0 time = 110
* CHECK dout1_11 vdout1_11ck10 = 0 time = 110
* CHECK dout1_12 vdout1_12ck10 = 1.8 time = 110
* CHECK dout1_13 vdout1_13ck10 = 1.8 time = 110
* CHECK dout1_14 vdout1_14ck10 = 0 time = 110
* CHECK dout1_15 vdout1_15ck10 = 1.8 time = 110
* CHECK dout1_16 vdout1_16ck10 = 0 time = 110
* CHECK dout1_17 vdout1_17ck10 = 1.8 time = 110
* CHECK dout1_18 vdout1_18ck10 = 1.8 time = 110
* CHECK dout1_19 vdout1_19ck10 = 0 time = 110
* CHECK dout1_20 vdout1_20ck10 = 0 time = 110
* CHECK dout1_21 vdout1_21ck10 = 0 time = 110
* CHECK dout1_22 vdout1_22ck10 = 1.8 time = 110
* CHECK dout1_23 vdout1_23ck10 = 1.8 time = 110
* CHECK dout1_24 vdout1_24ck10 = 0 time = 110
* CHECK dout1_25 vdout1_25ck10 = 1.8 time = 110
* CHECK dout1_26 vdout1_26ck10 = 1.8 time = 110
* CHECK dout1_27 vdout1_27ck10 = 1.8 time = 110
* CHECK dout1_28 vdout1_28ck10 = 0 time = 110
* CHECK dout1_29 vdout1_29ck10 = 1.8 time = 110
* CHECK dout1_30 vdout1_30ck10 = 0 time = 110
* CHECK dout1_31 vdout1_31ck10 = 0 time = 110
* CHECK dout1_0 vdout1_0ck11 = 0 time = 120
* CHECK dout1_1 vdout1_1ck11 = 1.8 time = 120
* CHECK dout1_2 vdout1_2ck11 = 0 time = 120
* CHECK dout1_3 vdout1_3ck11 = 1.8 time = 120
* CHECK dout1_4 vdout1_4ck11 = 0 time = 120
* CHECK dout1_5 vdout1_5ck11 = 1.8 time = 120
* CHECK dout1_6 vdout1_6ck11 = 0 time = 120
* CHECK dout1_7 vdout1_7ck11 = 1.8 time = 120
* CHECK dout1_8 vdout1_8ck11 = 0 time = 120
* CHECK dout1_9 vdout1_9ck11 = 1.8 time = 120
* CHECK dout1_10 vdout1_10ck11 = 0 time = 120
* CHECK dout1_11 vdout1_11ck11 = 0 time = 120
* CHECK dout1_12 vdout1_12ck11 = 1.8 time = 120
* CHECK dout1_13 vdout1_13ck11 = 1.8 time = 120
* CHECK dout1_14 vdout1_14ck11 = 0 time = 120
* CHECK dout1_15 vdout1_15ck11 = 1.8 time = 120
* CHECK dout1_16 vdout1_16ck11 = 0 time = 120
* CHECK dout1_17 vdout1_17ck11 = 1.8 time = 120
* CHECK dout1_18 vdout1_18ck11 = 1.8 time = 120
* CHECK dout1_19 vdout1_19ck11 = 0 time = 120
* CHECK dout1_20 vdout1_20ck11 = 0 time = 120
* CHECK dout1_21 vdout1_21ck11 = 0 time = 120
* CHECK dout1_22 vdout1_22ck11 = 1.8 time = 120
* CHECK dout1_23 vdout1_23ck11 = 1.8 time = 120
* CHECK dout1_24 vdout1_24ck11 = 0 time = 120
* CHECK dout1_25 vdout1_25ck11 = 1.8 time = 120
* CHECK dout1_26 vdout1_26ck11 = 1.8 time = 120
* CHECK dout1_27 vdout1_27ck11 = 1.8 time = 120
* CHECK dout1_28 vdout1_28ck11 = 0 time = 120
* CHECK dout1_29 vdout1_29ck11 = 1.8 time = 120
* CHECK dout1_30 vdout1_30ck11 = 0 time = 120
* CHECK dout1_31 vdout1_31ck11 = 0 time = 120
* CHECK dout0_0 vdout0_0ck13 = 0 time = 140
* CHECK dout0_1 vdout0_1ck13 = 1.8 time = 140
* CHECK dout0_2 vdout0_2ck13 = 0 time = 140
* CHECK dout0_3 vdout0_3ck13 = 1.8 time = 140
* CHECK dout0_4 vdout0_4ck13 = 0 time = 140
* CHECK dout0_5 vdout0_5ck13 = 1.8 time = 140
* CHECK dout0_6 vdout0_6ck13 = 0 time = 140
* CHECK dout0_7 vdout0_7ck13 = 1.8 time = 140
* CHECK dout0_8 vdout0_8ck13 = 0 time = 140
* CHECK dout0_9 vdout0_9ck13 = 1.8 time = 140
* CHECK dout0_10 vdout0_10ck13 = 0 time = 140
* CHECK dout0_11 vdout0_11ck13 = 0 time = 140
* CHECK dout0_12 vdout0_12ck13 = 1.8 time = 140
* CHECK dout0_13 vdout0_13ck13 = 1.8 time = 140
* CHECK dout0_14 vdout0_14ck13 = 0 time = 140
* CHECK dout0_15 vdout0_15ck13 = 1.8 time = 140
* CHECK dout0_16 vdout0_16ck13 = 0 time = 140
* CHECK dout0_17 vdout0_17ck13 = 1.8 time = 140
* CHECK dout0_18 vdout0_18ck13 = 1.8 time = 140
* CHECK dout0_19 vdout0_19ck13 = 0 time = 140
* CHECK dout0_20 vdout0_20ck13 = 0 time = 140
* CHECK dout0_21 vdout0_21ck13 = 0 time = 140
* CHECK dout0_22 vdout0_22ck13 = 1.8 time = 140
* CHECK dout0_23 vdout0_23ck13 = 1.8 time = 140
* CHECK dout0_24 vdout0_24ck13 = 0 time = 140
* CHECK dout0_25 vdout0_25ck13 = 1.8 time = 140
* CHECK dout0_26 vdout0_26ck13 = 1.8 time = 140
* CHECK dout0_27 vdout0_27ck13 = 1.8 time = 140
* CHECK dout0_28 vdout0_28ck13 = 0 time = 140
* CHECK dout0_29 vdout0_29ck13 = 1.8 time = 140
* CHECK dout0_30 vdout0_30ck13 = 0 time = 140
* CHECK dout0_31 vdout0_31ck13 = 0 time = 140
* CHECK dout1_0 vdout1_0ck13 = 0 time = 140
* CHECK dout1_1 vdout1_1ck13 = 1.8 time = 140
* CHECK dout1_2 vdout1_2ck13 = 1.8 time = 140
* CHECK dout1_3 vdout1_3ck13 = 0 time = 140
* CHECK dout1_4 vdout1_4ck13 = 1.8 time = 140
* CHECK dout1_5 vdout1_5ck13 = 1.8 time = 140
* CHECK dout1_6 vdout1_6ck13 = 0 time = 140
* CHECK dout1_7 vdout1_7ck13 = 1.8 time = 140
* CHECK dout1_8 vdout1_8ck13 = 0 time = 140
* CHECK dout1_9 vdout1_9ck13 = 1.8 time = 140
* CHECK dout1_10 vdout1_10ck13 = 0 time = 140
* CHECK dout1_11 vdout1_11ck13 = 0 time = 140
* CHECK dout1_12 vdout1_12ck13 = 1.8 time = 140
* CHECK dout1_13 vdout1_13ck13 = 1.8 time = 140
* CHECK dout1_14 vdout1_14ck13 = 1.8 time = 140
* CHECK dout1_15 vdout1_15ck13 = 0 time = 140
* CHECK dout1_16 vdout1_16ck13 = 1.8 time = 140
* CHECK dout1_17 vdout1_17ck13 = 0 time = 140
* CHECK dout1_18 vdout1_18ck13 = 1.8 time = 140
* CHECK dout1_19 vdout1_19ck13 = 1.8 time = 140
* CHECK dout1_20 vdout1_20ck13 = 1.8 time = 140
* CHECK dout1_21 vdout1_21ck13 = 0 time = 140
* CHECK dout1_22 vdout1_22ck13 = 1.8 time = 140
* CHECK dout1_23 vdout1_23ck13 = 0 time = 140
* CHECK dout1_24 vdout1_24ck13 = 0 time = 140
* CHECK dout1_25 vdout1_25ck13 = 0 time = 140
* CHECK dout1_26 vdout1_26ck13 = 0 time = 140
* CHECK dout1_27 vdout1_27ck13 = 1.8 time = 140
* CHECK dout1_28 vdout1_28ck13 = 1.8 time = 140
* CHECK dout1_29 vdout1_29ck13 = 1.8 time = 140
* CHECK dout1_30 vdout1_30ck13 = 1.8 time = 140
* CHECK dout1_31 vdout1_31ck13 = 1.8 time = 140
* CHECK dout0_0 vdout0_0ck14 = 1.8 time = 150
* CHECK dout0_1 vdout0_1ck14 = 0 time = 150
* CHECK dout0_2 vdout0_2ck14 = 0 time = 150
* CHECK dout0_3 vdout0_3ck14 = 0 time = 150
* CHECK dout0_4 vdout0_4ck14 = 1.8 time = 150
* CHECK dout0_5 vdout0_5ck14 = 1.8 time = 150
* CHECK dout0_6 vdout0_6ck14 = 1.8 time = 150
* CHECK dout0_7 vdout0_7ck14 = 0 time = 150
* CHECK dout0_8 vdout0_8ck14 = 0 time = 150
* CHECK dout0_9 vdout0_9ck14 = 1.8 time = 150
* CHECK dout0_10 vdout0_10ck14 = 1.8 time = 150
* CHECK dout0_11 vdout0_11ck14 = 0 time = 150
* CHECK dout0_12 vdout0_12ck14 = 0 time = 150
* CHECK dout0_13 vdout0_13ck14 = 0 time = 150
* CHECK dout0_14 vdout0_14ck14 = 1.8 time = 150
* CHECK dout0_15 vdout0_15ck14 = 1.8 time = 150
* CHECK dout0_16 vdout0_16ck14 = 1.8 time = 150
* CHECK dout0_17 vdout0_17ck14 = 0 time = 150
* CHECK dout0_18 vdout0_18ck14 = 1.8 time = 150
* CHECK dout0_19 vdout0_19ck14 = 1.8 time = 150
* CHECK dout0_20 vdout0_20ck14 = 1.8 time = 150
* CHECK dout0_21 vdout0_21ck14 = 1.8 time = 150
* CHECK dout0_22 vdout0_22ck14 = 1.8 time = 150
* CHECK dout0_23 vdout0_23ck14 = 1.8 time = 150
* CHECK dout0_24 vdout0_24ck14 = 1.8 time = 150
* CHECK dout0_25 vdout0_25ck14 = 1.8 time = 150
* CHECK dout0_26 vdout0_26ck14 = 1.8 time = 150
* CHECK dout0_27 vdout0_27ck14 = 0 time = 150
* CHECK dout0_28 vdout0_28ck14 = 1.8 time = 150
* CHECK dout0_29 vdout0_29ck14 = 1.8 time = 150
* CHECK dout0_30 vdout0_30ck14 = 1.8 time = 150
* CHECK dout0_31 vdout0_31ck14 = 0 time = 150
* CHECK dout1_0 vdout1_0ck14 = 0 time = 150
* CHECK dout1_1 vdout1_1ck14 = 1.8 time = 150
* CHECK dout1_2 vdout1_2ck14 = 0 time = 150
* CHECK dout1_3 vdout1_3ck14 = 1.8 time = 150
* CHECK dout1_4 vdout1_4ck14 = 0 time = 150
* CHECK dout1_5 vdout1_5ck14 = 1.8 time = 150
* CHECK dout1_6 vdout1_6ck14 = 0 time = 150
* CHECK dout1_7 vdout1_7ck14 = 1.8 time = 150
* CHECK dout1_8 vdout1_8ck14 = 0 time = 150
* CHECK dout1_9 vdout1_9ck14 = 1.8 time = 150
* CHECK dout1_10 vdout1_10ck14 = 0 time = 150
* CHECK dout1_11 vdout1_11ck14 = 0 time = 150
* CHECK dout1_12 vdout1_12ck14 = 1.8 time = 150
* CHECK dout1_13 vdout1_13ck14 = 1.8 time = 150
* CHECK dout1_14 vdout1_14ck14 = 0 time = 150
* CHECK dout1_15 vdout1_15ck14 = 1.8 time = 150
* CHECK dout1_16 vdout1_16ck14 = 0 time = 150
* CHECK dout1_17 vdout1_17ck14 = 1.8 time = 150
* CHECK dout1_18 vdout1_18ck14 = 1.8 time = 150
* CHECK dout1_19 vdout1_19ck14 = 0 time = 150
* CHECK dout1_20 vdout1_20ck14 = 0 time = 150
* CHECK dout1_21 vdout1_21ck14 = 0 time = 150
* CHECK dout1_22 vdout1_22ck14 = 1.8 time = 150
* CHECK dout1_23 vdout1_23ck14 = 1.8 time = 150
* CHECK dout1_24 vdout1_24ck14 = 0 time = 150
* CHECK dout1_25 vdout1_25ck14 = 1.8 time = 150
* CHECK dout1_26 vdout1_26ck14 = 1.8 time = 150
* CHECK dout1_27 vdout1_27ck14 = 1.8 time = 150
* CHECK dout1_28 vdout1_28ck14 = 0 time = 150
* CHECK dout1_29 vdout1_29ck14 = 1.8 time = 150
* CHECK dout1_30 vdout1_30ck14 = 0 time = 150
* CHECK dout1_31 vdout1_31ck14 = 0 time = 150
* CHECK dout1_0 vdout1_0ck16 = 1.8 time = 170
* CHECK dout1_1 vdout1_1ck16 = 0 time = 170
* CHECK dout1_2 vdout1_2ck16 = 0 time = 170
* CHECK dout1_3 vdout1_3ck16 = 0 time = 170
* CHECK dout1_4 vdout1_4ck16 = 1.8 time = 170
* CHECK dout1_5 vdout1_5ck16 = 1.8 time = 170
* CHECK dout1_6 vdout1_6ck16 = 1.8 time = 170
* CHECK dout1_7 vdout1_7ck16 = 0 time = 170
* CHECK dout1_8 vdout1_8ck16 = 0 time = 170
* CHECK dout1_9 vdout1_9ck16 = 1.8 time = 170
* CHECK dout1_10 vdout1_10ck16 = 1.8 time = 170
* CHECK dout1_11 vdout1_11ck16 = 0 time = 170
* CHECK dout1_12 vdout1_12ck16 = 0 time = 170
* CHECK dout1_13 vdout1_13ck16 = 0 time = 170
* CHECK dout1_14 vdout1_14ck16 = 1.8 time = 170
* CHECK dout1_15 vdout1_15ck16 = 1.8 time = 170
* CHECK dout1_16 vdout1_16ck16 = 1.8 time = 170
* CHECK dout1_17 vdout1_17ck16 = 0 time = 170
* CHECK dout1_18 vdout1_18ck16 = 1.8 time = 170
* CHECK dout1_19 vdout1_19ck16 = 1.8 time = 170
* CHECK dout1_20 vdout1_20ck16 = 1.8 time = 170
* CHECK dout1_21 vdout1_21ck16 = 1.8 time = 170
* CHECK dout1_22 vdout1_22ck16 = 1.8 time = 170
* CHECK dout1_23 vdout1_23ck16 = 1.8 time = 170
* CHECK dout1_24 vdout1_24ck16 = 1.8 time = 170
* CHECK dout1_25 vdout1_25ck16 = 1.8 time = 170
* CHECK dout1_26 vdout1_26ck16 = 1.8 time = 170
* CHECK dout1_27 vdout1_27ck16 = 0 time = 170
* CHECK dout1_28 vdout1_28ck16 = 1.8 time = 170
* CHECK dout1_29 vdout1_29ck16 = 1.8 time = 170
* CHECK dout1_30 vdout1_30ck16 = 1.8 time = 170
* CHECK dout1_31 vdout1_31ck16 = 0 time = 170
* CHECK dout0_0 vdout0_0ck17 = 0 time = 180
* CHECK dout0_1 vdout0_1ck17 = 1.8 time = 180
* CHECK dout0_2 vdout0_2ck17 = 1.8 time = 180
* CHECK dout0_3 vdout0_3ck17 = 0 time = 180
* CHECK dout0_4 vdout0_4ck17 = 1.8 time = 180
* CHECK dout0_5 vdout0_5ck17 = 1.8 time = 180
* CHECK dout0_6 vdout0_6ck17 = 0 time = 180
* CHECK dout0_7 vdout0_7ck17 = 1.8 time = 180
* CHECK dout0_8 vdout0_8ck17 = 0 time = 180
* CHECK dout0_9 vdout0_9ck17 = 1.8 time = 180
* CHECK dout0_10 vdout0_10ck17 = 0 time = 180
* CHECK dout0_11 vdout0_11ck17 = 0 time = 180
* CHECK dout0_12 vdout0_12ck17 = 1.8 time = 180
* CHECK dout0_13 vdout0_13ck17 = 1.8 time = 180
* CHECK dout0_14 vdout0_14ck17 = 1.8 time = 180
* CHECK dout0_15 vdout0_15ck17 = 0 time = 180
* CHECK dout0_16 vdout0_16ck17 = 1.8 time = 180
* CHECK dout0_17 vdout0_17ck17 = 0 time = 180
* CHECK dout0_18 vdout0_18ck17 = 1.8 time = 180
* CHECK dout0_19 vdout0_19ck17 = 1.8 time = 180
* CHECK dout0_20 vdout0_20ck17 = 1.8 time = 180
* CHECK dout0_21 vdout0_21ck17 = 0 time = 180
* CHECK dout0_22 vdout0_22ck17 = 1.8 time = 180
* CHECK dout0_23 vdout0_23ck17 = 0 time = 180
* CHECK dout0_24 vdout0_24ck17 = 0 time = 180
* CHECK dout0_25 vdout0_25ck17 = 0 time = 180
* CHECK dout0_26 vdout0_26ck17 = 0 time = 180
* CHECK dout0_27 vdout0_27ck17 = 1.8 time = 180
* CHECK dout0_28 vdout0_28ck17 = 1.8 time = 180
* CHECK dout0_29 vdout0_29ck17 = 1.8 time = 180
* CHECK dout0_30 vdout0_30ck17 = 1.8 time = 180
* CHECK dout0_31 vdout0_31ck17 = 1.8 time = 180
* CHECK dout1_0 vdout1_0ck17 = 1.8 time = 180
* CHECK dout1_1 vdout1_1ck17 = 0 time = 180
* CHECK dout1_2 vdout1_2ck17 = 0 time = 180
* CHECK dout1_3 vdout1_3ck17 = 0 time = 180
* CHECK dout1_4 vdout1_4ck17 = 1.8 time = 180
* CHECK dout1_5 vdout1_5ck17 = 1.8 time = 180
* CHECK dout1_6 vdout1_6ck17 = 1.8 time = 180
* CHECK dout1_7 vdout1_7ck17 = 0 time = 180
* CHECK dout1_8 vdout1_8ck17 = 0 time = 180
* CHECK dout1_9 vdout1_9ck17 = 1.8 time = 180
* CHECK dout1_10 vdout1_10ck17 = 1.8 time = 180
* CHECK dout1_11 vdout1_11ck17 = 0 time = 180
* CHECK dout1_12 vdout1_12ck17 = 0 time = 180
* CHECK dout1_13 vdout1_13ck17 = 0 time = 180
* CHECK dout1_14 vdout1_14ck17 = 1.8 time = 180
* CHECK dout1_15 vdout1_15ck17 = 1.8 time = 180
* CHECK dout1_16 vdout1_16ck17 = 1.8 time = 180
* CHECK dout1_17 vdout1_17ck17 = 0 time = 180
* CHECK dout1_18 vdout1_18ck17 = 1.8 time = 180
* CHECK dout1_19 vdout1_19ck17 = 1.8 time = 180
* CHECK dout1_20 vdout1_20ck17 = 1.8 time = 180
* CHECK dout1_21 vdout1_21ck17 = 1.8 time = 180
* CHECK dout1_22 vdout1_22ck17 = 1.8 time = 180
* CHECK dout1_23 vdout1_23ck17 = 1.8 time = 180
* CHECK dout1_24 vdout1_24ck17 = 1.8 time = 180
* CHECK dout1_25 vdout1_25ck17 = 1.8 time = 180
* CHECK dout1_26 vdout1_26ck17 = 1.8 time = 180
* CHECK dout1_27 vdout1_27ck17 = 0 time = 180
* CHECK dout1_28 vdout1_28ck17 = 1.8 time = 180
* CHECK dout1_29 vdout1_29ck17 = 1.8 time = 180
* CHECK dout1_30 vdout1_30ck17 = 1.8 time = 180
* CHECK dout1_31 vdout1_31ck17 = 0 time = 180
* CHECK dout0_0 vdout0_0ck18 = 1.8 time = 190
* CHECK dout0_1 vdout0_1ck18 = 0 time = 190
* CHECK dout0_2 vdout0_2ck18 = 0 time = 190
* CHECK dout0_3 vdout0_3ck18 = 0 time = 190
* CHECK dout0_4 vdout0_4ck18 = 1.8 time = 190
* CHECK dout0_5 vdout0_5ck18 = 1.8 time = 190
* CHECK dout0_6 vdout0_6ck18 = 1.8 time = 190
* CHECK dout0_7 vdout0_7ck18 = 0 time = 190
* CHECK dout0_8 vdout0_8ck18 = 0 time = 190
* CHECK dout0_9 vdout0_9ck18 = 1.8 time = 190
* CHECK dout0_10 vdout0_10ck18 = 1.8 time = 190
* CHECK dout0_11 vdout0_11ck18 = 0 time = 190
* CHECK dout0_12 vdout0_12ck18 = 0 time = 190
* CHECK dout0_13 vdout0_13ck18 = 0 time = 190
* CHECK dout0_14 vdout0_14ck18 = 1.8 time = 190
* CHECK dout0_15 vdout0_15ck18 = 1.8 time = 190
* CHECK dout0_16 vdout0_16ck18 = 1.8 time = 190
* CHECK dout0_17 vdout0_17ck18 = 0 time = 190
* CHECK dout0_18 vdout0_18ck18 = 1.8 time = 190
* CHECK dout0_19 vdout0_19ck18 = 1.8 time = 190
* CHECK dout0_20 vdout0_20ck18 = 1.8 time = 190
* CHECK dout0_21 vdout0_21ck18 = 1.8 time = 190
* CHECK dout0_22 vdout0_22ck18 = 1.8 time = 190
* CHECK dout0_23 vdout0_23ck18 = 1.8 time = 190
* CHECK dout0_24 vdout0_24ck18 = 1.8 time = 190
* CHECK dout0_25 vdout0_25ck18 = 1.8 time = 190
* CHECK dout0_26 vdout0_26ck18 = 1.8 time = 190
* CHECK dout0_27 vdout0_27ck18 = 0 time = 190
* CHECK dout0_28 vdout0_28ck18 = 1.8 time = 190
* CHECK dout0_29 vdout0_29ck18 = 1.8 time = 190
* CHECK dout0_30 vdout0_30ck18 = 1.8 time = 190
* CHECK dout0_31 vdout0_31ck18 = 0 time = 190
* CHECK dout0_0 vdout0_0ck19 = 0 time = 200
* CHECK dout0_1 vdout0_1ck19 = 1.8 time = 200
* CHECK dout0_2 vdout0_2ck19 = 1.8 time = 200
* CHECK dout0_3 vdout0_3ck19 = 0 time = 200
* CHECK dout0_4 vdout0_4ck19 = 1.8 time = 200
* CHECK dout0_5 vdout0_5ck19 = 1.8 time = 200
* CHECK dout0_6 vdout0_6ck19 = 0 time = 200
* CHECK dout0_7 vdout0_7ck19 = 1.8 time = 200
* CHECK dout0_8 vdout0_8ck19 = 0 time = 200
* CHECK dout0_9 vdout0_9ck19 = 1.8 time = 200
* CHECK dout0_10 vdout0_10ck19 = 0 time = 200
* CHECK dout0_11 vdout0_11ck19 = 0 time = 200
* CHECK dout0_12 vdout0_12ck19 = 1.8 time = 200
* CHECK dout0_13 vdout0_13ck19 = 1.8 time = 200
* CHECK dout0_14 vdout0_14ck19 = 1.8 time = 200
* CHECK dout0_15 vdout0_15ck19 = 0 time = 200
* CHECK dout0_16 vdout0_16ck19 = 1.8 time = 200
* CHECK dout0_17 vdout0_17ck19 = 0 time = 200
* CHECK dout0_18 vdout0_18ck19 = 1.8 time = 200
* CHECK dout0_19 vdout0_19ck19 = 1.8 time = 200
* CHECK dout0_20 vdout0_20ck19 = 1.8 time = 200
* CHECK dout0_21 vdout0_21ck19 = 0 time = 200
* CHECK dout0_22 vdout0_22ck19 = 1.8 time = 200
* CHECK dout0_23 vdout0_23ck19 = 0 time = 200
* CHECK dout0_24 vdout0_24ck19 = 0 time = 200
* CHECK dout0_25 vdout0_25ck19 = 0 time = 200
* CHECK dout0_26 vdout0_26ck19 = 0 time = 200
* CHECK dout0_27 vdout0_27ck19 = 1.8 time = 200
* CHECK dout0_28 vdout0_28ck19 = 1.8 time = 200
* CHECK dout0_29 vdout0_29ck19 = 1.8 time = 200
* CHECK dout0_30 vdout0_30ck19 = 1.8 time = 200
* CHECK dout0_31 vdout0_31ck19 = 1.8 time = 200
* CHECK dout1_0 vdout1_0ck19 = 0 time = 200
* CHECK dout1_1 vdout1_1ck19 = 1.8 time = 200
* CHECK dout1_2 vdout1_2ck19 = 1.8 time = 200
* CHECK dout1_3 vdout1_3ck19 = 0 time = 200
* CHECK dout1_4 vdout1_4ck19 = 1.8 time = 200
* CHECK dout1_5 vdout1_5ck19 = 1.8 time = 200
* CHECK dout1_6 vdout1_6ck19 = 0 time = 200
* CHECK dout1_7 vdout1_7ck19 = 1.8 time = 200
* CHECK dout1_8 vdout1_8ck19 = 0 time = 200
* CHECK dout1_9 vdout1_9ck19 = 1.8 time = 200
* CHECK dout1_10 vdout1_10ck19 = 0 time = 200
* CHECK dout1_11 vdout1_11ck19 = 0 time = 200
* CHECK dout1_12 vdout1_12ck19 = 1.8 time = 200
* CHECK dout1_13 vdout1_13ck19 = 1.8 time = 200
* CHECK dout1_14 vdout1_14ck19 = 1.8 time = 200
* CHECK dout1_15 vdout1_15ck19 = 0 time = 200
* CHECK dout1_16 vdout1_16ck19 = 1.8 time = 200
* CHECK dout1_17 vdout1_17ck19 = 0 time = 200
* CHECK dout1_18 vdout1_18ck19 = 1.8 time = 200
* CHECK dout1_19 vdout1_19ck19 = 1.8 time = 200
* CHECK dout1_20 vdout1_20ck19 = 1.8 time = 200
* CHECK dout1_21 vdout1_21ck19 = 0 time = 200
* CHECK dout1_22 vdout1_22ck19 = 1.8 time = 200
* CHECK dout1_23 vdout1_23ck19 = 0 time = 200
* CHECK dout1_24 vdout1_24ck19 = 0 time = 200
* CHECK dout1_25 vdout1_25ck19 = 0 time = 200
* CHECK dout1_26 vdout1_26ck19 = 0 time = 200
* CHECK dout1_27 vdout1_27ck19 = 1.8 time = 200
* CHECK dout1_28 vdout1_28ck19 = 1.8 time = 200
* CHECK dout1_29 vdout1_29ck19 = 1.8 time = 200
* CHECK dout1_30 vdout1_30ck19 = 1.8 time = 200
* CHECK dout1_31 vdout1_31ck19 = 1.8 time = 200
* CHECK dout0_0 vdout0_0ck21 = 1.8 time = 220
* CHECK dout0_1 vdout0_1ck21 = 0 time = 220
* CHECK dout0_2 vdout0_2ck21 = 0 time = 220
* CHECK dout0_3 vdout0_3ck21 = 0 time = 220
* CHECK dout0_4 vdout0_4ck21 = 1.8 time = 220
* CHECK dout0_5 vdout0_5ck21 = 1.8 time = 220
* CHECK dout0_6 vdout0_6ck21 = 1.8 time = 220
* CHECK dout0_7 vdout0_7ck21 = 0 time = 220
* CHECK dout0_8 vdout0_8ck21 = 0 time = 220
* CHECK dout0_9 vdout0_9ck21 = 1.8 time = 220
* CHECK dout0_10 vdout0_10ck21 = 1.8 time = 220
* CHECK dout0_11 vdout0_11ck21 = 0 time = 220
* CHECK dout0_12 vdout0_12ck21 = 0 time = 220
* CHECK dout0_13 vdout0_13ck21 = 0 time = 220
* CHECK dout0_14 vdout0_14ck21 = 1.8 time = 220
* CHECK dout0_15 vdout0_15ck21 = 1.8 time = 220
* CHECK dout0_16 vdout0_16ck21 = 1.8 time = 220
* CHECK dout0_17 vdout0_17ck21 = 0 time = 220
* CHECK dout0_18 vdout0_18ck21 = 1.8 time = 220
* CHECK dout0_19 vdout0_19ck21 = 1.8 time = 220
* CHECK dout0_20 vdout0_20ck21 = 1.8 time = 220
* CHECK dout0_21 vdout0_21ck21 = 1.8 time = 220
* CHECK dout0_22 vdout0_22ck21 = 1.8 time = 220
* CHECK dout0_23 vdout0_23ck21 = 1.8 time = 220
* CHECK dout0_24 vdout0_24ck21 = 1.8 time = 220
* CHECK dout0_25 vdout0_25ck21 = 1.8 time = 220
* CHECK dout0_26 vdout0_26ck21 = 1.8 time = 220
* CHECK dout0_27 vdout0_27ck21 = 0 time = 220
* CHECK dout0_28 vdout0_28ck21 = 1.8 time = 220
* CHECK dout0_29 vdout0_29ck21 = 1.8 time = 220
* CHECK dout0_30 vdout0_30ck21 = 1.8 time = 220
* CHECK dout0_31 vdout0_31ck21 = 0 time = 220
* CHECK dout1_0 vdout1_0ck22 = 1.8 time = 230
* CHECK dout1_1 vdout1_1ck22 = 0 time = 230
* CHECK dout1_2 vdout1_2ck22 = 0 time = 230
* CHECK dout1_3 vdout1_3ck22 = 0 time = 230
* CHECK dout1_4 vdout1_4ck22 = 1.8 time = 230
* CHECK dout1_5 vdout1_5ck22 = 1.8 time = 230
* CHECK dout1_6 vdout1_6ck22 = 1.8 time = 230
* CHECK dout1_7 vdout1_7ck22 = 0 time = 230
* CHECK dout1_8 vdout1_8ck22 = 0 time = 230
* CHECK dout1_9 vdout1_9ck22 = 1.8 time = 230
* CHECK dout1_10 vdout1_10ck22 = 1.8 time = 230
* CHECK dout1_11 vdout1_11ck22 = 0 time = 230
* CHECK dout1_12 vdout1_12ck22 = 0 time = 230
* CHECK dout1_13 vdout1_13ck22 = 0 time = 230
* CHECK dout1_14 vdout1_14ck22 = 1.8 time = 230
* CHECK dout1_15 vdout1_15ck22 = 1.8 time = 230
* CHECK dout1_16 vdout1_16ck22 = 1.8 time = 230
* CHECK dout1_17 vdout1_17ck22 = 0 time = 230
* CHECK dout1_18 vdout1_18ck22 = 1.8 time = 230
* CHECK dout1_19 vdout1_19ck22 = 1.8 time = 230
* CHECK dout1_20 vdout1_20ck22 = 1.8 time = 230
* CHECK dout1_21 vdout1_21ck22 = 1.8 time = 230
* CHECK dout1_22 vdout1_22ck22 = 1.8 time = 230
* CHECK dout1_23 vdout1_23ck22 = 1.8 time = 230
* CHECK dout1_24 vdout1_24ck22 = 1.8 time = 230
* CHECK dout1_25 vdout1_25ck22 = 1.8 time = 230
* CHECK dout1_26 vdout1_26ck22 = 1.8 time = 230
* CHECK dout1_27 vdout1_27ck22 = 0 time = 230
* CHECK dout1_28 vdout1_28ck22 = 1.8 time = 230
* CHECK dout1_29 vdout1_29ck22 = 1.8 time = 230
* CHECK dout1_30 vdout1_30ck22 = 1.8 time = 230
* CHECK dout1_31 vdout1_31ck22 = 0 time = 230
* CHECK dout0_0 vdout0_0ck23 = 0 time = 240
* CHECK dout0_1 vdout0_1ck23 = 1.8 time = 240
* CHECK dout0_2 vdout0_2ck23 = 0 time = 240
* CHECK dout0_3 vdout0_3ck23 = 1.8 time = 240
* CHECK dout0_4 vdout0_4ck23 = 0 time = 240
* CHECK dout0_5 vdout0_5ck23 = 1.8 time = 240
* CHECK dout0_6 vdout0_6ck23 = 0 time = 240
* CHECK dout0_7 vdout0_7ck23 = 1.8 time = 240
* CHECK dout0_8 vdout0_8ck23 = 0 time = 240
* CHECK dout0_9 vdout0_9ck23 = 1.8 time = 240
* CHECK dout0_10 vdout0_10ck23 = 0 time = 240
* CHECK dout0_11 vdout0_11ck23 = 0 time = 240
* CHECK dout0_12 vdout0_12ck23 = 1.8 time = 240
* CHECK dout0_13 vdout0_13ck23 = 1.8 time = 240
* CHECK dout0_14 vdout0_14ck23 = 0 time = 240
* CHECK dout0_15 vdout0_15ck23 = 1.8 time = 240
* CHECK dout0_16 vdout0_16ck23 = 0 time = 240
* CHECK dout0_17 vdout0_17ck23 = 1.8 time = 240
* CHECK dout0_18 vdout0_18ck23 = 1.8 time = 240
* CHECK dout0_19 vdout0_19ck23 = 0 time = 240
* CHECK dout0_20 vdout0_20ck23 = 0 time = 240
* CHECK dout0_21 vdout0_21ck23 = 0 time = 240
* CHECK dout0_22 vdout0_22ck23 = 1.8 time = 240
* CHECK dout0_23 vdout0_23ck23 = 1.8 time = 240
* CHECK dout0_24 vdout0_24ck23 = 0 time = 240
* CHECK dout0_25 vdout0_25ck23 = 1.8 time = 240
* CHECK dout0_26 vdout0_26ck23 = 1.8 time = 240
* CHECK dout0_27 vdout0_27ck23 = 1.8 time = 240
* CHECK dout0_28 vdout0_28ck23 = 0 time = 240
* CHECK dout0_29 vdout0_29ck23 = 1.8 time = 240
* CHECK dout0_30 vdout0_30ck23 = 0 time = 240
* CHECK dout0_31 vdout0_31ck23 = 0 time = 240
* CHECK dout1_0 vdout1_0ck23 = 1.8 time = 240
* CHECK dout1_1 vdout1_1ck23 = 0 time = 240
* CHECK dout1_2 vdout1_2ck23 = 1.8 time = 240
* CHECK dout1_3 vdout1_3ck23 = 0 time = 240
* CHECK dout1_4 vdout1_4ck23 = 0 time = 240
* CHECK dout1_5 vdout1_5ck23 = 1.8 time = 240
* CHECK dout1_6 vdout1_6ck23 = 1.8 time = 240
* CHECK dout1_7 vdout1_7ck23 = 0 time = 240
* CHECK dout1_8 vdout1_8ck23 = 0 time = 240
* CHECK dout1_9 vdout1_9ck23 = 1.8 time = 240
* CHECK dout1_10 vdout1_10ck23 = 1.8 time = 240
* CHECK dout1_11 vdout1_11ck23 = 1.8 time = 240
* CHECK dout1_12 vdout1_12ck23 = 0 time = 240
* CHECK dout1_13 vdout1_13ck23 = 0 time = 240
* CHECK dout1_14 vdout1_14ck23 = 1.8 time = 240
* CHECK dout1_15 vdout1_15ck23 = 0 time = 240
* CHECK dout1_16 vdout1_16ck23 = 0 time = 240
* CHECK dout1_17 vdout1_17ck23 = 0 time = 240
* CHECK dout1_18 vdout1_18ck23 = 1.8 time = 240
* CHECK dout1_19 vdout1_19ck23 = 1.8 time = 240
* CHECK dout1_20 vdout1_20ck23 = 1.8 time = 240
* CHECK dout1_21 vdout1_21ck23 = 1.8 time = 240
* CHECK dout1_22 vdout1_22ck23 = 0 time = 240
* CHECK dout1_23 vdout1_23ck23 = 0 time = 240
* CHECK dout1_24 vdout1_24ck23 = 1.8 time = 240
* CHECK dout1_25 vdout1_25ck23 = 0 time = 240
* CHECK dout1_26 vdout1_26ck23 = 0 time = 240
* CHECK dout1_27 vdout1_27ck23 = 1.8 time = 240
* CHECK dout1_28 vdout1_28ck23 = 0 time = 240
* CHECK dout1_29 vdout1_29ck23 = 1.8 time = 240
* CHECK dout1_30 vdout1_30ck23 = 0 time = 240
* CHECK dout1_31 vdout1_31ck23 = 0 time = 240
* CHECK dout1_0 vdout1_0ck24 = 0 time = 250
* CHECK dout1_1 vdout1_1ck24 = 0 time = 250
* CHECK dout1_2 vdout1_2ck24 = 0 time = 250
* CHECK dout1_3 vdout1_3ck24 = 1.8 time = 250
* CHECK dout1_4 vdout1_4ck24 = 1.8 time = 250
* CHECK dout1_5 vdout1_5ck24 = 1.8 time = 250
* CHECK dout1_6 vdout1_6ck24 = 0 time = 250
* CHECK dout1_7 vdout1_7ck24 = 1.8 time = 250
* CHECK dout1_8 vdout1_8ck24 = 0 time = 250
* CHECK dout1_9 vdout1_9ck24 = 1.8 time = 250
* CHECK dout1_10 vdout1_10ck24 = 1.8 time = 250
* CHECK dout1_11 vdout1_11ck24 = 1.8 time = 250
* CHECK dout1_12 vdout1_12ck24 = 0 time = 250
* CHECK dout1_13 vdout1_13ck24 = 0 time = 250
* CHECK dout1_14 vdout1_14ck24 = 0 time = 250
* CHECK dout1_15 vdout1_15ck24 = 1.8 time = 250
* CHECK dout1_16 vdout1_16ck24 = 0 time = 250
* CHECK dout1_17 vdout1_17ck24 = 0 time = 250
* CHECK dout1_18 vdout1_18ck24 = 1.8 time = 250
* CHECK dout1_19 vdout1_19ck24 = 1.8 time = 250
* CHECK dout1_20 vdout1_20ck24 = 1.8 time = 250
* CHECK dout1_21 vdout1_21ck24 = 0 time = 250
* CHECK dout1_22 vdout1_22ck24 = 0 time = 250
* CHECK dout1_23 vdout1_23ck24 = 1.8 time = 250
* CHECK dout1_24 vdout1_24ck24 = 1.8 time = 250
* CHECK dout1_25 vdout1_25ck24 = 1.8 time = 250
* CHECK dout1_26 vdout1_26ck24 = 1.8 time = 250
* CHECK dout1_27 vdout1_27ck24 = 1.8 time = 250
* CHECK dout1_28 vdout1_28ck24 = 1.8 time = 250
* CHECK dout1_29 vdout1_29ck24 = 0 time = 250
* CHECK dout1_30 vdout1_30ck24 = 1.8 time = 250
* CHECK dout1_31 vdout1_31ck24 = 1.8 time = 250
* CHECK dout1_0 vdout1_0ck25 = 0 time = 260
* CHECK dout1_1 vdout1_1ck25 = 0 time = 260
* CHECK dout1_2 vdout1_2ck25 = 0 time = 260
* CHECK dout1_3 vdout1_3ck25 = 1.8 time = 260
* CHECK dout1_4 vdout1_4ck25 = 1.8 time = 260
* CHECK dout1_5 vdout1_5ck25 = 1.8 time = 260
* CHECK dout1_6 vdout1_6ck25 = 0 time = 260
* CHECK dout1_7 vdout1_7ck25 = 1.8 time = 260
* CHECK dout1_8 vdout1_8ck25 = 0 time = 260
* CHECK dout1_9 vdout1_9ck25 = 1.8 time = 260
* CHECK dout1_10 vdout1_10ck25 = 1.8 time = 260
* CHECK dout1_11 vdout1_11ck25 = 1.8 time = 260
* CHECK dout1_12 vdout1_12ck25 = 0 time = 260
* CHECK dout1_13 vdout1_13ck25 = 0 time = 260
* CHECK dout1_14 vdout1_14ck25 = 0 time = 260
* CHECK dout1_15 vdout1_15ck25 = 1.8 time = 260
* CHECK dout1_16 vdout1_16ck25 = 0 time = 260
* CHECK dout1_17 vdout1_17ck25 = 0 time = 260
* CHECK dout1_18 vdout1_18ck25 = 1.8 time = 260
* CHECK dout1_19 vdout1_19ck25 = 1.8 time = 260
* CHECK dout1_20 vdout1_20ck25 = 1.8 time = 260
* CHECK dout1_21 vdout1_21ck25 = 0 time = 260
* CHECK dout1_22 vdout1_22ck25 = 0 time = 260
* CHECK dout1_23 vdout1_23ck25 = 1.8 time = 260
* CHECK dout1_24 vdout1_24ck25 = 1.8 time = 260
* CHECK dout1_25 vdout1_25ck25 = 1.8 time = 260
* CHECK dout1_26 vdout1_26ck25 = 1.8 time = 260
* CHECK dout1_27 vdout1_27ck25 = 1.8 time = 260
* CHECK dout1_28 vdout1_28ck25 = 1.8 time = 260
* CHECK dout1_29 vdout1_29ck25 = 0 time = 260
* CHECK dout1_30 vdout1_30ck25 = 1.8 time = 260
* CHECK dout1_31 vdout1_31ck25 = 1.8 time = 260
* CHECK dout1_0 vdout1_0ck26 = 1.8 time = 270
* CHECK dout1_1 vdout1_1ck26 = 0 time = 270
* CHECK dout1_2 vdout1_2ck26 = 1.8 time = 270
* CHECK dout1_3 vdout1_3ck26 = 0 time = 270
* CHECK dout1_4 vdout1_4ck26 = 0 time = 270
* CHECK dout1_5 vdout1_5ck26 = 1.8 time = 270
* CHECK dout1_6 vdout1_6ck26 = 1.8 time = 270
* CHECK dout1_7 vdout1_7ck26 = 0 time = 270
* CHECK dout1_8 vdout1_8ck26 = 0 time = 270
* CHECK dout1_9 vdout1_9ck26 = 1.8 time = 270
* CHECK dout1_10 vdout1_10ck26 = 1.8 time = 270
* CHECK dout1_11 vdout1_11ck26 = 1.8 time = 270
* CHECK dout1_12 vdout1_12ck26 = 0 time = 270
* CHECK dout1_13 vdout1_13ck26 = 0 time = 270
* CHECK dout1_14 vdout1_14ck26 = 1.8 time = 270
* CHECK dout1_15 vdout1_15ck26 = 0 time = 270
* CHECK dout1_16 vdout1_16ck26 = 0 time = 270
* CHECK dout1_17 vdout1_17ck26 = 0 time = 270
* CHECK dout1_18 vdout1_18ck26 = 1.8 time = 270
* CHECK dout1_19 vdout1_19ck26 = 1.8 time = 270
* CHECK dout1_20 vdout1_20ck26 = 1.8 time = 270
* CHECK dout1_21 vdout1_21ck26 = 1.8 time = 270
* CHECK dout1_22 vdout1_22ck26 = 0 time = 270
* CHECK dout1_23 vdout1_23ck26 = 0 time = 270
* CHECK dout1_24 vdout1_24ck26 = 1.8 time = 270
* CHECK dout1_25 vdout1_25ck26 = 0 time = 270
* CHECK dout1_26 vdout1_26ck26 = 0 time = 270
* CHECK dout1_27 vdout1_27ck26 = 1.8 time = 270
* CHECK dout1_28 vdout1_28ck26 = 0 time = 270
* CHECK dout1_29 vdout1_29ck26 = 1.8 time = 270
* CHECK dout1_30 vdout1_30ck26 = 0 time = 270
* CHECK dout1_31 vdout1_31ck26 = 0 time = 270
* CHECK dout0_0 vdout0_0ck27 = 1.8 time = 280
* CHECK dout0_1 vdout0_1ck27 = 0 time = 280
* CHECK dout0_2 vdout0_2ck27 = 1.8 time = 280
* CHECK dout0_3 vdout0_3ck27 = 0 time = 280
* CHECK dout0_4 vdout0_4ck27 = 0 time = 280
* CHECK dout0_5 vdout0_5ck27 = 1.8 time = 280
* CHECK dout0_6 vdout0_6ck27 = 1.8 time = 280
* CHECK dout0_7 vdout0_7ck27 = 0 time = 280
* CHECK dout0_8 vdout0_8ck27 = 0 time = 280
* CHECK dout0_9 vdout0_9ck27 = 1.8 time = 280
* CHECK dout0_10 vdout0_10ck27 = 1.8 time = 280
* CHECK dout0_11 vdout0_11ck27 = 1.8 time = 280
* CHECK dout0_12 vdout0_12ck27 = 0 time = 280
* CHECK dout0_13 vdout0_13ck27 = 0 time = 280
* CHECK dout0_14 vdout0_14ck27 = 1.8 time = 280
* CHECK dout0_15 vdout0_15ck27 = 0 time = 280
* CHECK dout0_16 vdout0_16ck27 = 0 time = 280
* CHECK dout0_17 vdout0_17ck27 = 0 time = 280
* CHECK dout0_18 vdout0_18ck27 = 1.8 time = 280
* CHECK dout0_19 vdout0_19ck27 = 1.8 time = 280
* CHECK dout0_20 vdout0_20ck27 = 1.8 time = 280
* CHECK dout0_21 vdout0_21ck27 = 1.8 time = 280
* CHECK dout0_22 vdout0_22ck27 = 0 time = 280
* CHECK dout0_23 vdout0_23ck27 = 0 time = 280
* CHECK dout0_24 vdout0_24ck27 = 1.8 time = 280
* CHECK dout0_25 vdout0_25ck27 = 0 time = 280
* CHECK dout0_26 vdout0_26ck27 = 0 time = 280
* CHECK dout0_27 vdout0_27ck27 = 1.8 time = 280
* CHECK dout0_28 vdout0_28ck27 = 0 time = 280
* CHECK dout0_29 vdout0_29ck27 = 1.8 time = 280
* CHECK dout0_30 vdout0_30ck27 = 0 time = 280
* CHECK dout0_31 vdout0_31ck27 = 0 time = 280
* CHECK dout0_0 vdout0_0ck28 = 0 time = 290
* CHECK dout0_1 vdout0_1ck28 = 1.8 time = 290
* CHECK dout0_2 vdout0_2ck28 = 0 time = 290
* CHECK dout0_3 vdout0_3ck28 = 1.8 time = 290
* CHECK dout0_4 vdout0_4ck28 = 0 time = 290
* CHECK dout0_5 vdout0_5ck28 = 1.8 time = 290
* CHECK dout0_6 vdout0_6ck28 = 0 time = 290
* CHECK dout0_7 vdout0_7ck28 = 1.8 time = 290
* CHECK dout0_8 vdout0_8ck28 = 0 time = 290
* CHECK dout0_9 vdout0_9ck28 = 1.8 time = 290
* CHECK dout0_10 vdout0_10ck28 = 0 time = 290
* CHECK dout0_11 vdout0_11ck28 = 0 time = 290
* CHECK dout0_12 vdout0_12ck28 = 1.8 time = 290
* CHECK dout0_13 vdout0_13ck28 = 1.8 time = 290
* CHECK dout0_14 vdout0_14ck28 = 0 time = 290
* CHECK dout0_15 vdout0_15ck28 = 1.8 time = 290
* CHECK dout0_16 vdout0_16ck28 = 0 time = 290
* CHECK dout0_17 vdout0_17ck28 = 1.8 time = 290
* CHECK dout0_18 vdout0_18ck28 = 1.8 time = 290
* CHECK dout0_19 vdout0_19ck28 = 0 time = 290
* CHECK dout0_20 vdout0_20ck28 = 0 time = 290
* CHECK dout0_21 vdout0_21ck28 = 0 time = 290
* CHECK dout0_22 vdout0_22ck28 = 1.8 time = 290
* CHECK dout0_23 vdout0_23ck28 = 1.8 time = 290
* CHECK dout0_24 vdout0_24ck28 = 0 time = 290
* CHECK dout0_25 vdout0_25ck28 = 1.8 time = 290
* CHECK dout0_26 vdout0_26ck28 = 1.8 time = 290
* CHECK dout0_27 vdout0_27ck28 = 1.8 time = 290
* CHECK dout0_28 vdout0_28ck28 = 0 time = 290
* CHECK dout0_29 vdout0_29ck28 = 1.8 time = 290
* CHECK dout0_30 vdout0_30ck28 = 0 time = 290
* CHECK dout0_31 vdout0_31ck28 = 0 time = 290
* CHECK dout1_0 vdout1_0ck28 = 1.8 time = 290
* CHECK dout1_1 vdout1_1ck28 = 0 time = 290
* CHECK dout1_2 vdout1_2ck28 = 1.8 time = 290
* CHECK dout1_3 vdout1_3ck28 = 0 time = 290
* CHECK dout1_4 vdout1_4ck28 = 0 time = 290
* CHECK dout1_5 vdout1_5ck28 = 1.8 time = 290
* CHECK dout1_6 vdout1_6ck28 = 1.8 time = 290
* CHECK dout1_7 vdout1_7ck28 = 0 time = 290
* CHECK dout1_8 vdout1_8ck28 = 0 time = 290
* CHECK dout1_9 vdout1_9ck28 = 1.8 time = 290
* CHECK dout1_10 vdout1_10ck28 = 1.8 time = 290
* CHECK dout1_11 vdout1_11ck28 = 1.8 time = 290
* CHECK dout1_12 vdout1_12ck28 = 0 time = 290
* CHECK dout1_13 vdout1_13ck28 = 0 time = 290
* CHECK dout1_14 vdout1_14ck28 = 1.8 time = 290
* CHECK dout1_15 vdout1_15ck28 = 0 time = 290
* CHECK dout1_16 vdout1_16ck28 = 0 time = 290
* CHECK dout1_17 vdout1_17ck28 = 0 time = 290
* CHECK dout1_18 vdout1_18ck28 = 1.8 time = 290
* CHECK dout1_19 vdout1_19ck28 = 1.8 time = 290
* CHECK dout1_20 vdout1_20ck28 = 1.8 time = 290
* CHECK dout1_21 vdout1_21ck28 = 1.8 time = 290
* CHECK dout1_22 vdout1_22ck28 = 0 time = 290
* CHECK dout1_23 vdout1_23ck28 = 0 time = 290
* CHECK dout1_24 vdout1_24ck28 = 1.8 time = 290
* CHECK dout1_25 vdout1_25ck28 = 0 time = 290
* CHECK dout1_26 vdout1_26ck28 = 0 time = 290
* CHECK dout1_27 vdout1_27ck28 = 1.8 time = 290
* CHECK dout1_28 vdout1_28ck28 = 0 time = 290
* CHECK dout1_29 vdout1_29ck28 = 1.8 time = 290
* CHECK dout1_30 vdout1_30ck28 = 0 time = 290
* CHECK dout1_31 vdout1_31ck28 = 0 time = 290
* CHECK dout1_0 vdout1_0ck29 = 0 time = 300
* CHECK dout1_1 vdout1_1ck29 = 0 time = 300
* CHECK dout1_2 vdout1_2ck29 = 0 time = 300
* CHECK dout1_3 vdout1_3ck29 = 1.8 time = 300
* CHECK dout1_4 vdout1_4ck29 = 1.8 time = 300
* CHECK dout1_5 vdout1_5ck29 = 1.8 time = 300
* CHECK dout1_6 vdout1_6ck29 = 0 time = 300
* CHECK dout1_7 vdout1_7ck29 = 1.8 time = 300
* CHECK dout1_8 vdout1_8ck29 = 0 time = 300
* CHECK dout1_9 vdout1_9ck29 = 1.8 time = 300
* CHECK dout1_10 vdout1_10ck29 = 1.8 time = 300
* CHECK dout1_11 vdout1_11ck29 = 1.8 time = 300
* CHECK dout1_12 vdout1_12ck29 = 0 time = 300
* CHECK dout1_13 vdout1_13ck29 = 0 time = 300
* CHECK dout1_14 vdout1_14ck29 = 0 time = 300
* CHECK dout1_15 vdout1_15ck29 = 1.8 time = 300
* CHECK dout1_16 vdout1_16ck29 = 0 time = 300
* CHECK dout1_17 vdout1_17ck29 = 0 time = 300
* CHECK dout1_18 vdout1_18ck29 = 1.8 time = 300
* CHECK dout1_19 vdout1_19ck29 = 1.8 time = 300
* CHECK dout1_20 vdout1_20ck29 = 1.8 time = 300
* CHECK dout1_21 vdout1_21ck29 = 0 time = 300
* CHECK dout1_22 vdout1_22ck29 = 0 time = 300
* CHECK dout1_23 vdout1_23ck29 = 1.8 time = 300
* CHECK dout1_24 vdout1_24ck29 = 1.8 time = 300
* CHECK dout1_25 vdout1_25ck29 = 1.8 time = 300
* CHECK dout1_26 vdout1_26ck29 = 1.8 time = 300
* CHECK dout1_27 vdout1_27ck29 = 1.8 time = 300
* CHECK dout1_28 vdout1_28ck29 = 1.8 time = 300
* CHECK dout1_29 vdout1_29ck29 = 0 time = 300
* CHECK dout1_30 vdout1_30ck29 = 1.8 time = 300
* CHECK dout1_31 vdout1_31ck29 = 1.8 time = 300
* CHECK dout0_0 vdout0_0ck30 = 1.8 time = 310
* CHECK dout0_1 vdout0_1ck30 = 0 time = 310
* CHECK dout0_2 vdout0_2ck30 = 0 time = 310
* CHECK dout0_3 vdout0_3ck30 = 0 time = 310
* CHECK dout0_4 vdout0_4ck30 = 1.8 time = 310
* CHECK dout0_5 vdout0_5ck30 = 1.8 time = 310
* CHECK dout0_6 vdout0_6ck30 = 1.8 time = 310
* CHECK dout0_7 vdout0_7ck30 = 0 time = 310
* CHECK dout0_8 vdout0_8ck30 = 1.8 time = 310
* CHECK dout0_9 vdout0_9ck30 = 1.8 time = 310
* CHECK dout0_10 vdout0_10ck30 = 1.8 time = 310
* CHECK dout0_11 vdout0_11ck30 = 1.8 time = 310
* CHECK dout0_12 vdout0_12ck30 = 1.8 time = 310
* CHECK dout0_13 vdout0_13ck30 = 0 time = 310
* CHECK dout0_14 vdout0_14ck30 = 1.8 time = 310
* CHECK dout0_15 vdout0_15ck30 = 1.8 time = 310
* CHECK dout0_16 vdout0_16ck30 = 0 time = 310
* CHECK dout0_17 vdout0_17ck30 = 0 time = 310
* CHECK dout0_18 vdout0_18ck30 = 1.8 time = 310
* CHECK dout0_19 vdout0_19ck30 = 1.8 time = 310
* CHECK dout0_20 vdout0_20ck30 = 1.8 time = 310
* CHECK dout0_21 vdout0_21ck30 = 0 time = 310
* CHECK dout0_22 vdout0_22ck30 = 0 time = 310
* CHECK dout0_23 vdout0_23ck30 = 1.8 time = 310
* CHECK dout0_24 vdout0_24ck30 = 1.8 time = 310
* CHECK dout0_25 vdout0_25ck30 = 1.8 time = 310
* CHECK dout0_26 vdout0_26ck30 = 1.8 time = 310
* CHECK dout0_27 vdout0_27ck30 = 0 time = 310
* CHECK dout0_28 vdout0_28ck30 = 1.8 time = 310
* CHECK dout0_29 vdout0_29ck30 = 1.8 time = 310
* CHECK dout0_30 vdout0_30ck30 = 1.8 time = 310
* CHECK dout0_31 vdout0_31ck30 = 0 time = 310
* CHECK dout0_0 vdout0_0ck31 = 1.8 time = 320
* CHECK dout0_1 vdout0_1ck31 = 0 time = 320
* CHECK dout0_2 vdout0_2ck31 = 1.8 time = 320
* CHECK dout0_3 vdout0_3ck31 = 0 time = 320
* CHECK dout0_4 vdout0_4ck31 = 0 time = 320
* CHECK dout0_5 vdout0_5ck31 = 1.8 time = 320
* CHECK dout0_6 vdout0_6ck31 = 1.8 time = 320
* CHECK dout0_7 vdout0_7ck31 = 0 time = 320
* CHECK dout0_8 vdout0_8ck31 = 0 time = 320
* CHECK dout0_9 vdout0_9ck31 = 1.8 time = 320
* CHECK dout0_10 vdout0_10ck31 = 1.8 time = 320
* CHECK dout0_11 vdout0_11ck31 = 1.8 time = 320
* CHECK dout0_12 vdout0_12ck31 = 0 time = 320
* CHECK dout0_13 vdout0_13ck31 = 0 time = 320
* CHECK dout0_14 vdout0_14ck31 = 1.8 time = 320
* CHECK dout0_15 vdout0_15ck31 = 0 time = 320
* CHECK dout0_16 vdout0_16ck31 = 0 time = 320
* CHECK dout0_17 vdout0_17ck31 = 0 time = 320
* CHECK dout0_18 vdout0_18ck31 = 1.8 time = 320
* CHECK dout0_19 vdout0_19ck31 = 1.8 time = 320
* CHECK dout0_20 vdout0_20ck31 = 1.8 time = 320
* CHECK dout0_21 vdout0_21ck31 = 1.8 time = 320
* CHECK dout0_22 vdout0_22ck31 = 0 time = 320
* CHECK dout0_23 vdout0_23ck31 = 0 time = 320
* CHECK dout0_24 vdout0_24ck31 = 1.8 time = 320
* CHECK dout0_25 vdout0_25ck31 = 0 time = 320
* CHECK dout0_26 vdout0_26ck31 = 0 time = 320
* CHECK dout0_27 vdout0_27ck31 = 1.8 time = 320
* CHECK dout0_28 vdout0_28ck31 = 0 time = 320
* CHECK dout0_29 vdout0_29ck31 = 1.8 time = 320
* CHECK dout0_30 vdout0_30ck31 = 0 time = 320
* CHECK dout0_31 vdout0_31ck31 = 0 time = 320
* CHECK dout1_0 vdout1_0ck33 = 0 time = 340
* CHECK dout1_1 vdout1_1ck33 = 0 time = 340
* CHECK dout1_2 vdout1_2ck33 = 0 time = 340
* CHECK dout1_3 vdout1_3ck33 = 1.8 time = 340
* CHECK dout1_4 vdout1_4ck33 = 1.8 time = 340
* CHECK dout1_5 vdout1_5ck33 = 1.8 time = 340
* CHECK dout1_6 vdout1_6ck33 = 0 time = 340
* CHECK dout1_7 vdout1_7ck33 = 1.8 time = 340
* CHECK dout1_8 vdout1_8ck33 = 0 time = 340
* CHECK dout1_9 vdout1_9ck33 = 1.8 time = 340
* CHECK dout1_10 vdout1_10ck33 = 1.8 time = 340
* CHECK dout1_11 vdout1_11ck33 = 1.8 time = 340
* CHECK dout1_12 vdout1_12ck33 = 0 time = 340
* CHECK dout1_13 vdout1_13ck33 = 0 time = 340
* CHECK dout1_14 vdout1_14ck33 = 0 time = 340
* CHECK dout1_15 vdout1_15ck33 = 1.8 time = 340
* CHECK dout1_16 vdout1_16ck33 = 0 time = 340
* CHECK dout1_17 vdout1_17ck33 = 0 time = 340
* CHECK dout1_18 vdout1_18ck33 = 1.8 time = 340
* CHECK dout1_19 vdout1_19ck33 = 1.8 time = 340
* CHECK dout1_20 vdout1_20ck33 = 1.8 time = 340
* CHECK dout1_21 vdout1_21ck33 = 0 time = 340
* CHECK dout1_22 vdout1_22ck33 = 0 time = 340
* CHECK dout1_23 vdout1_23ck33 = 1.8 time = 340
* CHECK dout1_24 vdout1_24ck33 = 1.8 time = 340
* CHECK dout1_25 vdout1_25ck33 = 1.8 time = 340
* CHECK dout1_26 vdout1_26ck33 = 1.8 time = 340
* CHECK dout1_27 vdout1_27ck33 = 1.8 time = 340
* CHECK dout1_28 vdout1_28ck33 = 1.8 time = 340
* CHECK dout1_29 vdout1_29ck33 = 0 time = 340
* CHECK dout1_30 vdout1_30ck33 = 1.8 time = 340
* CHECK dout1_31 vdout1_31ck33 = 1.8 time = 340
* CHECK dout0_0 vdout0_0ck34 = 0 time = 350
* CHECK dout0_1 vdout0_1ck34 = 1.8 time = 350
* CHECK dout0_2 vdout0_2ck34 = 0 time = 350
* CHECK dout0_3 vdout0_3ck34 = 0 time = 350
* CHECK dout0_4 vdout0_4ck34 = 1.8 time = 350
* CHECK dout0_5 vdout0_5ck34 = 0 time = 350
* CHECK dout0_6 vdout0_6ck34 = 0 time = 350
* CHECK dout0_7 vdout0_7ck34 = 1.8 time = 350
* CHECK dout0_8 vdout0_8ck34 = 1.8 time = 350
* CHECK dout0_9 vdout0_9ck34 = 1.8 time = 350
* CHECK dout0_10 vdout0_10ck34 = 1.8 time = 350
* CHECK dout0_11 vdout0_11ck34 = 1.8 time = 350
* CHECK dout0_12 vdout0_12ck34 = 1.8 time = 350
* CHECK dout0_13 vdout0_13ck34 = 0 time = 350
* CHECK dout0_14 vdout0_14ck34 = 1.8 time = 350
* CHECK dout0_15 vdout0_15ck34 = 1.8 time = 350
* CHECK dout0_16 vdout0_16ck34 = 0 time = 350
* CHECK dout0_17 vdout0_17ck34 = 0 time = 350
* CHECK dout0_18 vdout0_18ck34 = 1.8 time = 350
* CHECK dout0_19 vdout0_19ck34 = 1.8 time = 350
* CHECK dout0_20 vdout0_20ck34 = 1.8 time = 350
* CHECK dout0_21 vdout0_21ck34 = 0 time = 350
* CHECK dout0_22 vdout0_22ck34 = 0 time = 350
* CHECK dout0_23 vdout0_23ck34 = 1.8 time = 350
* CHECK dout0_24 vdout0_24ck34 = 1.8 time = 350
* CHECK dout0_25 vdout0_25ck34 = 1.8 time = 350
* CHECK dout0_26 vdout0_26ck34 = 1.8 time = 350
* CHECK dout0_27 vdout0_27ck34 = 0 time = 350
* CHECK dout0_28 vdout0_28ck34 = 1.8 time = 350
* CHECK dout0_29 vdout0_29ck34 = 1.8 time = 350
* CHECK dout0_30 vdout0_30ck34 = 1.8 time = 350
* CHECK dout0_31 vdout0_31ck34 = 0 time = 350
* CHECK dout1_0 vdout1_0ck34 = 0 time = 350
* CHECK dout1_1 vdout1_1ck34 = 1.8 time = 350
* CHECK dout1_2 vdout1_2ck34 = 0 time = 350
* CHECK dout1_3 vdout1_3ck34 = 0 time = 350
* CHECK dout1_4 vdout1_4ck34 = 1.8 time = 350
* CHECK dout1_5 vdout1_5ck34 = 0 time = 350
* CHECK dout1_6 vdout1_6ck34 = 0 time = 350
* CHECK dout1_7 vdout1_7ck34 = 1.8 time = 350
* CHECK dout1_8 vdout1_8ck34 = 1.8 time = 350
* CHECK dout1_9 vdout1_9ck34 = 1.8 time = 350
* CHECK dout1_10 vdout1_10ck34 = 1.8 time = 350
* CHECK dout1_11 vdout1_11ck34 = 1.8 time = 350
* CHECK dout1_12 vdout1_12ck34 = 1.8 time = 350
* CHECK dout1_13 vdout1_13ck34 = 0 time = 350
* CHECK dout1_14 vdout1_14ck34 = 1.8 time = 350
* CHECK dout1_15 vdout1_15ck34 = 1.8 time = 350
* CHECK dout1_16 vdout1_16ck34 = 0 time = 350
* CHECK dout1_17 vdout1_17ck34 = 0 time = 350
* CHECK dout1_18 vdout1_18ck34 = 1.8 time = 350
* CHECK dout1_19 vdout1_19ck34 = 1.8 time = 350
* CHECK dout1_20 vdout1_20ck34 = 1.8 time = 350
* CHECK dout1_21 vdout1_21ck34 = 0 time = 350
* CHECK dout1_22 vdout1_22ck34 = 0 time = 350
* CHECK dout1_23 vdout1_23ck34 = 1.8 time = 350
* CHECK dout1_24 vdout1_24ck34 = 1.8 time = 350
* CHECK dout1_25 vdout1_25ck34 = 1.8 time = 350
* CHECK dout1_26 vdout1_26ck34 = 1.8 time = 350
* CHECK dout1_27 vdout1_27ck34 = 0 time = 350
* CHECK dout1_28 vdout1_28ck34 = 1.8 time = 350
* CHECK dout1_29 vdout1_29ck34 = 1.8 time = 350
* CHECK dout1_30 vdout1_30ck34 = 1.8 time = 350
* CHECK dout1_31 vdout1_31ck34 = 0 time = 350
* CHECK dout0_0 vdout0_0ck35 = 0 time = 360
* CHECK dout0_1 vdout0_1ck35 = 0 time = 360
* CHECK dout0_2 vdout0_2ck35 = 0 time = 360
* CHECK dout0_3 vdout0_3ck35 = 1.8 time = 360
* CHECK dout0_4 vdout0_4ck35 = 1.8 time = 360
* CHECK dout0_5 vdout0_5ck35 = 1.8 time = 360
* CHECK dout0_6 vdout0_6ck35 = 0 time = 360
* CHECK dout0_7 vdout0_7ck35 = 1.8 time = 360
* CHECK dout0_8 vdout0_8ck35 = 0 time = 360
* CHECK dout0_9 vdout0_9ck35 = 1.8 time = 360
* CHECK dout0_10 vdout0_10ck35 = 1.8 time = 360
* CHECK dout0_11 vdout0_11ck35 = 1.8 time = 360
* CHECK dout0_12 vdout0_12ck35 = 0 time = 360
* CHECK dout0_13 vdout0_13ck35 = 0 time = 360
* CHECK dout0_14 vdout0_14ck35 = 0 time = 360
* CHECK dout0_15 vdout0_15ck35 = 1.8 time = 360
* CHECK dout0_16 vdout0_16ck35 = 0 time = 360
* CHECK dout0_17 vdout0_17ck35 = 0 time = 360
* CHECK dout0_18 vdout0_18ck35 = 1.8 time = 360
* CHECK dout0_19 vdout0_19ck35 = 1.8 time = 360
* CHECK dout0_20 vdout0_20ck35 = 1.8 time = 360
* CHECK dout0_21 vdout0_21ck35 = 0 time = 360
* CHECK dout0_22 vdout0_22ck35 = 0 time = 360
* CHECK dout0_23 vdout0_23ck35 = 1.8 time = 360
* CHECK dout0_24 vdout0_24ck35 = 1.8 time = 360
* CHECK dout0_25 vdout0_25ck35 = 1.8 time = 360
* CHECK dout0_26 vdout0_26ck35 = 1.8 time = 360
* CHECK dout0_27 vdout0_27ck35 = 1.8 time = 360
* CHECK dout0_28 vdout0_28ck35 = 1.8 time = 360
* CHECK dout0_29 vdout0_29ck35 = 0 time = 360
* CHECK dout0_30 vdout0_30ck35 = 1.8 time = 360
* CHECK dout0_31 vdout0_31ck35 = 1.8 time = 360
* CHECK dout0_0 vdout0_0ck37 = 0 time = 380
* CHECK dout0_1 vdout0_1ck37 = 1.8 time = 380
* CHECK dout0_2 vdout0_2ck37 = 0 time = 380
* CHECK dout0_3 vdout0_3ck37 = 0 time = 380
* CHECK dout0_4 vdout0_4ck37 = 1.8 time = 380
* CHECK dout0_5 vdout0_5ck37 = 0 time = 380
* CHECK dout0_6 vdout0_6ck37 = 0 time = 380
* CHECK dout0_7 vdout0_7ck37 = 1.8 time = 380
* CHECK dout0_8 vdout0_8ck37 = 1.8 time = 380
* CHECK dout0_9 vdout0_9ck37 = 1.8 time = 380
* CHECK dout0_10 vdout0_10ck37 = 1.8 time = 380
* CHECK dout0_11 vdout0_11ck37 = 1.8 time = 380
* CHECK dout0_12 vdout0_12ck37 = 1.8 time = 380
* CHECK dout0_13 vdout0_13ck37 = 0 time = 380
* CHECK dout0_14 vdout0_14ck37 = 1.8 time = 380
* CHECK dout0_15 vdout0_15ck37 = 1.8 time = 380
* CHECK dout0_16 vdout0_16ck37 = 0 time = 380
* CHECK dout0_17 vdout0_17ck37 = 0 time = 380
* CHECK dout0_18 vdout0_18ck37 = 1.8 time = 380
* CHECK dout0_19 vdout0_19ck37 = 1.8 time = 380
* CHECK dout0_20 vdout0_20ck37 = 1.8 time = 380
* CHECK dout0_21 vdout0_21ck37 = 0 time = 380
* CHECK dout0_22 vdout0_22ck37 = 0 time = 380
* CHECK dout0_23 vdout0_23ck37 = 1.8 time = 380
* CHECK dout0_24 vdout0_24ck37 = 1.8 time = 380
* CHECK dout0_25 vdout0_25ck37 = 1.8 time = 380
* CHECK dout0_26 vdout0_26ck37 = 1.8 time = 380
* CHECK dout0_27 vdout0_27ck37 = 0 time = 380
* CHECK dout0_28 vdout0_28ck37 = 1.8 time = 380
* CHECK dout0_29 vdout0_29ck37 = 1.8 time = 380
* CHECK dout0_30 vdout0_30ck37 = 1.8 time = 380
* CHECK dout0_31 vdout0_31ck37 = 0 time = 380
* CHECK dout1_0 vdout1_0ck38 = 0 time = 390
* CHECK dout1_1 vdout1_1ck38 = 0 time = 390
* CHECK dout1_2 vdout1_2ck38 = 0 time = 390
* CHECK dout1_3 vdout1_3ck38 = 1.8 time = 390
* CHECK dout1_4 vdout1_4ck38 = 1.8 time = 390
* CHECK dout1_5 vdout1_5ck38 = 1.8 time = 390
* CHECK dout1_6 vdout1_6ck38 = 0 time = 390
* CHECK dout1_7 vdout1_7ck38 = 1.8 time = 390
* CHECK dout1_8 vdout1_8ck38 = 0 time = 390
* CHECK dout1_9 vdout1_9ck38 = 1.8 time = 390
* CHECK dout1_10 vdout1_10ck38 = 1.8 time = 390
* CHECK dout1_11 vdout1_11ck38 = 1.8 time = 390
* CHECK dout1_12 vdout1_12ck38 = 0 time = 390
* CHECK dout1_13 vdout1_13ck38 = 0 time = 390
* CHECK dout1_14 vdout1_14ck38 = 0 time = 390
* CHECK dout1_15 vdout1_15ck38 = 1.8 time = 390
* CHECK dout1_16 vdout1_16ck38 = 0 time = 390
* CHECK dout1_17 vdout1_17ck38 = 0 time = 390
* CHECK dout1_18 vdout1_18ck38 = 1.8 time = 390
* CHECK dout1_19 vdout1_19ck38 = 1.8 time = 390
* CHECK dout1_20 vdout1_20ck38 = 1.8 time = 390
* CHECK dout1_21 vdout1_21ck38 = 0 time = 390
* CHECK dout1_22 vdout1_22ck38 = 0 time = 390
* CHECK dout1_23 vdout1_23ck38 = 1.8 time = 390
* CHECK dout1_24 vdout1_24ck38 = 0 time = 390
* CHECK dout1_25 vdout1_25ck38 = 0 time = 390
* CHECK dout1_26 vdout1_26ck38 = 0 time = 390
* CHECK dout1_27 vdout1_27ck38 = 1.8 time = 390
* CHECK dout1_28 vdout1_28ck38 = 1.8 time = 390
* CHECK dout1_29 vdout1_29ck38 = 0 time = 390
* CHECK dout1_30 vdout1_30ck38 = 1.8 time = 390
* CHECK dout1_31 vdout1_31ck38 = 0 time = 390
* CHECK dout0_0 vdout0_0ck39 = 0 time = 400
* CHECK dout0_1 vdout0_1ck39 = 0 time = 400
* CHECK dout0_2 vdout0_2ck39 = 0 time = 400
* CHECK dout0_3 vdout0_3ck39 = 1.8 time = 400
* CHECK dout0_4 vdout0_4ck39 = 1.8 time = 400
* CHECK dout0_5 vdout0_5ck39 = 1.8 time = 400
* CHECK dout0_6 vdout0_6ck39 = 0 time = 400
* CHECK dout0_7 vdout0_7ck39 = 1.8 time = 400
* CHECK dout0_8 vdout0_8ck39 = 0 time = 400
* CHECK dout0_9 vdout0_9ck39 = 1.8 time = 400
* CHECK dout0_10 vdout0_10ck39 = 1.8 time = 400
* CHECK dout0_11 vdout0_11ck39 = 1.8 time = 400
* CHECK dout0_12 vdout0_12ck39 = 0 time = 400
* CHECK dout0_13 vdout0_13ck39 = 0 time = 400
* CHECK dout0_14 vdout0_14ck39 = 0 time = 400
* CHECK dout0_15 vdout0_15ck39 = 1.8 time = 400
* CHECK dout0_16 vdout0_16ck39 = 0 time = 400
* CHECK dout0_17 vdout0_17ck39 = 0 time = 400
* CHECK dout0_18 vdout0_18ck39 = 1.8 time = 400
* CHECK dout0_19 vdout0_19ck39 = 1.8 time = 400
* CHECK dout0_20 vdout0_20ck39 = 1.8 time = 400
* CHECK dout0_21 vdout0_21ck39 = 0 time = 400
* CHECK dout0_22 vdout0_22ck39 = 0 time = 400
* CHECK dout0_23 vdout0_23ck39 = 1.8 time = 400
* CHECK dout0_24 vdout0_24ck39 = 0 time = 400
* CHECK dout0_25 vdout0_25ck39 = 0 time = 400
* CHECK dout0_26 vdout0_26ck39 = 0 time = 400
* CHECK dout0_27 vdout0_27ck39 = 1.8 time = 400
* CHECK dout0_28 vdout0_28ck39 = 1.8 time = 400
* CHECK dout0_29 vdout0_29ck39 = 0 time = 400
* CHECK dout0_30 vdout0_30ck39 = 1.8 time = 400
* CHECK dout0_31 vdout0_31ck39 = 0 time = 400
* CHECK dout1_0 vdout1_0ck39 = 0 time = 400
* CHECK dout1_1 vdout1_1ck39 = 0 time = 400
* CHECK dout1_2 vdout1_2ck39 = 0 time = 400
* CHECK dout1_3 vdout1_3ck39 = 1.8 time = 400
* CHECK dout1_4 vdout1_4ck39 = 1.8 time = 400
* CHECK dout1_5 vdout1_5ck39 = 1.8 time = 400
* CHECK dout1_6 vdout1_6ck39 = 1.8 time = 400
* CHECK dout1_7 vdout1_7ck39 = 1.8 time = 400
* CHECK dout1_8 vdout1_8ck39 = 0 time = 400
* CHECK dout1_9 vdout1_9ck39 = 0 time = 400
* CHECK dout1_10 vdout1_10ck39 = 0 time = 400
* CHECK dout1_11 vdout1_11ck39 = 1.8 time = 400
* CHECK dout1_12 vdout1_12ck39 = 0 time = 400
* CHECK dout1_13 vdout1_13ck39 = 1.8 time = 400
* CHECK dout1_14 vdout1_14ck39 = 0 time = 400
* CHECK dout1_15 vdout1_15ck39 = 1.8 time = 400
* CHECK dout1_16 vdout1_16ck39 = 0 time = 400
* CHECK dout1_17 vdout1_17ck39 = 1.8 time = 400
* CHECK dout1_18 vdout1_18ck39 = 1.8 time = 400
* CHECK dout1_19 vdout1_19ck39 = 0 time = 400
* CHECK dout1_20 vdout1_20ck39 = 0 time = 400
* CHECK dout1_21 vdout1_21ck39 = 0 time = 400
* CHECK dout1_22 vdout1_22ck39 = 1.8 time = 400
* CHECK dout1_23 vdout1_23ck39 = 1.8 time = 400
* CHECK dout1_24 vdout1_24ck39 = 0 time = 400
* CHECK dout1_25 vdout1_25ck39 = 0 time = 400
* CHECK dout1_26 vdout1_26ck39 = 0 time = 400
* CHECK dout1_27 vdout1_27ck39 = 0 time = 400
* CHECK dout1_28 vdout1_28ck39 = 1.8 time = 400
* CHECK dout1_29 vdout1_29ck39 = 0 time = 400
* CHECK dout1_30 vdout1_30ck39 = 0 time = 400
* CHECK dout1_31 vdout1_31ck39 = 0 time = 400
* CHECK dout1_0 vdout1_0ck40 = 0 time = 410
* CHECK dout1_1 vdout1_1ck40 = 1.8 time = 410
* CHECK dout1_2 vdout1_2ck40 = 0 time = 410
* CHECK dout1_3 vdout1_3ck40 = 0 time = 410
* CHECK dout1_4 vdout1_4ck40 = 1.8 time = 410
* CHECK dout1_5 vdout1_5ck40 = 0 time = 410
* CHECK dout1_6 vdout1_6ck40 = 0 time = 410
* CHECK dout1_7 vdout1_7ck40 = 1.8 time = 410
* CHECK dout1_8 vdout1_8ck40 = 1.8 time = 410
* CHECK dout1_9 vdout1_9ck40 = 1.8 time = 410
* CHECK dout1_10 vdout1_10ck40 = 1.8 time = 410
* CHECK dout1_11 vdout1_11ck40 = 1.8 time = 410
* CHECK dout1_12 vdout1_12ck40 = 1.8 time = 410
* CHECK dout1_13 vdout1_13ck40 = 0 time = 410
* CHECK dout1_14 vdout1_14ck40 = 1.8 time = 410
* CHECK dout1_15 vdout1_15ck40 = 1.8 time = 410
* CHECK dout1_16 vdout1_16ck40 = 0 time = 410
* CHECK dout1_17 vdout1_17ck40 = 0 time = 410
* CHECK dout1_18 vdout1_18ck40 = 1.8 time = 410
* CHECK dout1_19 vdout1_19ck40 = 1.8 time = 410
* CHECK dout1_20 vdout1_20ck40 = 1.8 time = 410
* CHECK dout1_21 vdout1_21ck40 = 0 time = 410
* CHECK dout1_22 vdout1_22ck40 = 0 time = 410
* CHECK dout1_23 vdout1_23ck40 = 1.8 time = 410
* CHECK dout1_24 vdout1_24ck40 = 1.8 time = 410
* CHECK dout1_25 vdout1_25ck40 = 1.8 time = 410
* CHECK dout1_26 vdout1_26ck40 = 1.8 time = 410
* CHECK dout1_27 vdout1_27ck40 = 0 time = 410
* CHECK dout1_28 vdout1_28ck40 = 1.8 time = 410
* CHECK dout1_29 vdout1_29ck40 = 1.8 time = 410
* CHECK dout1_30 vdout1_30ck40 = 1.8 time = 410
* CHECK dout1_31 vdout1_31ck40 = 0 time = 410
* CHECK dout0_0 vdout0_0ck43 = 1.8 time = 440
* CHECK dout0_1 vdout0_1ck43 = 0 time = 440
* CHECK dout0_2 vdout0_2ck43 = 1.8 time = 440
* CHECK dout0_3 vdout0_3ck43 = 0 time = 440
* CHECK dout0_4 vdout0_4ck43 = 0 time = 440
* CHECK dout0_5 vdout0_5ck43 = 1.8 time = 440
* CHECK dout0_6 vdout0_6ck43 = 1.8 time = 440
* CHECK dout0_7 vdout0_7ck43 = 0 time = 440
* CHECK dout0_8 vdout0_8ck43 = 0 time = 440
* CHECK dout0_9 vdout0_9ck43 = 1.8 time = 440
* CHECK dout0_10 vdout0_10ck43 = 1.8 time = 440
* CHECK dout0_11 vdout0_11ck43 = 1.8 time = 440
* CHECK dout0_12 vdout0_12ck43 = 0 time = 440
* CHECK dout0_13 vdout0_13ck43 = 0 time = 440
* CHECK dout0_14 vdout0_14ck43 = 1.8 time = 440
* CHECK dout0_15 vdout0_15ck43 = 0 time = 440
* CHECK dout0_16 vdout0_16ck43 = 0 time = 440
* CHECK dout0_17 vdout0_17ck43 = 0 time = 440
* CHECK dout0_18 vdout0_18ck43 = 1.8 time = 440
* CHECK dout0_19 vdout0_19ck43 = 1.8 time = 440
* CHECK dout0_20 vdout0_20ck43 = 1.8 time = 440
* CHECK dout0_21 vdout0_21ck43 = 1.8 time = 440
* CHECK dout0_22 vdout0_22ck43 = 0 time = 440
* CHECK dout0_23 vdout0_23ck43 = 0 time = 440
* CHECK dout0_24 vdout0_24ck43 = 1.8 time = 440
* CHECK dout0_25 vdout0_25ck43 = 0 time = 440
* CHECK dout0_26 vdout0_26ck43 = 0 time = 440
* CHECK dout0_27 vdout0_27ck43 = 1.8 time = 440
* CHECK dout0_28 vdout0_28ck43 = 0 time = 440
* CHECK dout0_29 vdout0_29ck43 = 1.8 time = 440
* CHECK dout0_30 vdout0_30ck43 = 0 time = 440
* CHECK dout0_31 vdout0_31ck43 = 0 time = 440
* CHECK dout1_0 vdout1_0ck43 = 0 time = 440
* CHECK dout1_1 vdout1_1ck43 = 1.8 time = 440
* CHECK dout1_2 vdout1_2ck43 = 1.8 time = 440
* CHECK dout1_3 vdout1_3ck43 = 1.8 time = 440
* CHECK dout1_4 vdout1_4ck43 = 0 time = 440
* CHECK dout1_5 vdout1_5ck43 = 0 time = 440
* CHECK dout1_6 vdout1_6ck43 = 1.8 time = 440
* CHECK dout1_7 vdout1_7ck43 = 1.8 time = 440
* CHECK dout1_8 vdout1_8ck43 = 1.8 time = 440
* CHECK dout1_9 vdout1_9ck43 = 1.8 time = 440
* CHECK dout1_10 vdout1_10ck43 = 1.8 time = 440
* CHECK dout1_11 vdout1_11ck43 = 0 time = 440
* CHECK dout1_12 vdout1_12ck43 = 1.8 time = 440
* CHECK dout1_13 vdout1_13ck43 = 0 time = 440
* CHECK dout1_14 vdout1_14ck43 = 1.8 time = 440
* CHECK dout1_15 vdout1_15ck43 = 0 time = 440
* CHECK dout1_16 vdout1_16ck43 = 0 time = 440
* CHECK dout1_17 vdout1_17ck43 = 0 time = 440
* CHECK dout1_18 vdout1_18ck43 = 0 time = 440
* CHECK dout1_19 vdout1_19ck43 = 1.8 time = 440
* CHECK dout1_20 vdout1_20ck43 = 1.8 time = 440
* CHECK dout1_21 vdout1_21ck43 = 1.8 time = 440
* CHECK dout1_22 vdout1_22ck43 = 1.8 time = 440
* CHECK dout1_23 vdout1_23ck43 = 1.8 time = 440
* CHECK dout1_24 vdout1_24ck43 = 0 time = 440
* CHECK dout1_25 vdout1_25ck43 = 0 time = 440
* CHECK dout1_26 vdout1_26ck43 = 1.8 time = 440
* CHECK dout1_27 vdout1_27ck43 = 1.8 time = 440
* CHECK dout1_28 vdout1_28ck43 = 0 time = 440
* CHECK dout1_29 vdout1_29ck43 = 0 time = 440
* CHECK dout1_30 vdout1_30ck43 = 1.8 time = 440
* CHECK dout1_31 vdout1_31ck43 = 0 time = 440
* CHECK dout1_0 vdout1_0ck44 = 0 time = 450
* CHECK dout1_1 vdout1_1ck44 = 1.8 time = 450
* CHECK dout1_2 vdout1_2ck44 = 1.8 time = 450
* CHECK dout1_3 vdout1_3ck44 = 1.8 time = 450
* CHECK dout1_4 vdout1_4ck44 = 0 time = 450
* CHECK dout1_5 vdout1_5ck44 = 0 time = 450
* CHECK dout1_6 vdout1_6ck44 = 1.8 time = 450
* CHECK dout1_7 vdout1_7ck44 = 1.8 time = 450
* CHECK dout1_8 vdout1_8ck44 = 1.8 time = 450
* CHECK dout1_9 vdout1_9ck44 = 1.8 time = 450
* CHECK dout1_10 vdout1_10ck44 = 1.8 time = 450
* CHECK dout1_11 vdout1_11ck44 = 0 time = 450
* CHECK dout1_12 vdout1_12ck44 = 1.8 time = 450
* CHECK dout1_13 vdout1_13ck44 = 0 time = 450
* CHECK dout1_14 vdout1_14ck44 = 1.8 time = 450
* CHECK dout1_15 vdout1_15ck44 = 0 time = 450
* CHECK dout1_16 vdout1_16ck44 = 0 time = 450
* CHECK dout1_17 vdout1_17ck44 = 0 time = 450
* CHECK dout1_18 vdout1_18ck44 = 0 time = 450
* CHECK dout1_19 vdout1_19ck44 = 1.8 time = 450
* CHECK dout1_20 vdout1_20ck44 = 1.8 time = 450
* CHECK dout1_21 vdout1_21ck44 = 1.8 time = 450
* CHECK dout1_22 vdout1_22ck44 = 1.8 time = 450
* CHECK dout1_23 vdout1_23ck44 = 1.8 time = 450
* CHECK dout1_24 vdout1_24ck44 = 0 time = 450
* CHECK dout1_25 vdout1_25ck44 = 0 time = 450
* CHECK dout1_26 vdout1_26ck44 = 1.8 time = 450
* CHECK dout1_27 vdout1_27ck44 = 1.8 time = 450
* CHECK dout1_28 vdout1_28ck44 = 0 time = 450
* CHECK dout1_29 vdout1_29ck44 = 0 time = 450
* CHECK dout1_30 vdout1_30ck44 = 1.8 time = 450
* CHECK dout1_31 vdout1_31ck44 = 0 time = 450
* CHECK dout0_0 vdout0_0ck46 = 0 time = 470
* CHECK dout0_1 vdout0_1ck46 = 0 time = 470
* CHECK dout0_2 vdout0_2ck46 = 0 time = 470
* CHECK dout0_3 vdout0_3ck46 = 1.8 time = 470
* CHECK dout0_4 vdout0_4ck46 = 1.8 time = 470
* CHECK dout0_5 vdout0_5ck46 = 1.8 time = 470
* CHECK dout0_6 vdout0_6ck46 = 0 time = 470
* CHECK dout0_7 vdout0_7ck46 = 1.8 time = 470
* CHECK dout0_8 vdout0_8ck46 = 0 time = 470
* CHECK dout0_9 vdout0_9ck46 = 1.8 time = 470
* CHECK dout0_10 vdout0_10ck46 = 1.8 time = 470
* CHECK dout0_11 vdout0_11ck46 = 1.8 time = 470
* CHECK dout0_12 vdout0_12ck46 = 0 time = 470
* CHECK dout0_13 vdout0_13ck46 = 0 time = 470
* CHECK dout0_14 vdout0_14ck46 = 0 time = 470
* CHECK dout0_15 vdout0_15ck46 = 1.8 time = 470
* CHECK dout0_16 vdout0_16ck46 = 0 time = 470
* CHECK dout0_17 vdout0_17ck46 = 0 time = 470
* CHECK dout0_18 vdout0_18ck46 = 1.8 time = 470
* CHECK dout0_19 vdout0_19ck46 = 1.8 time = 470
* CHECK dout0_20 vdout0_20ck46 = 1.8 time = 470
* CHECK dout0_21 vdout0_21ck46 = 0 time = 470
* CHECK dout0_22 vdout0_22ck46 = 0 time = 470
* CHECK dout0_23 vdout0_23ck46 = 1.8 time = 470
* CHECK dout0_24 vdout0_24ck46 = 0 time = 470
* CHECK dout0_25 vdout0_25ck46 = 0 time = 470
* CHECK dout0_26 vdout0_26ck46 = 0 time = 470
* CHECK dout0_27 vdout0_27ck46 = 1.8 time = 470
* CHECK dout0_28 vdout0_28ck46 = 1.8 time = 470
* CHECK dout0_29 vdout0_29ck46 = 0 time = 470
* CHECK dout0_30 vdout0_30ck46 = 1.8 time = 470
* CHECK dout0_31 vdout0_31ck46 = 0 time = 470
* CHECK dout0_0 vdout0_0ck47 = 0 time = 480
* CHECK dout0_1 vdout0_1ck47 = 0 time = 480
* CHECK dout0_2 vdout0_2ck47 = 0 time = 480
* CHECK dout0_3 vdout0_3ck47 = 1.8 time = 480
* CHECK dout0_4 vdout0_4ck47 = 1.8 time = 480
* CHECK dout0_5 vdout0_5ck47 = 1.8 time = 480
* CHECK dout0_6 vdout0_6ck47 = 0 time = 480
* CHECK dout0_7 vdout0_7ck47 = 1.8 time = 480
* CHECK dout0_8 vdout0_8ck47 = 0 time = 480
* CHECK dout0_9 vdout0_9ck47 = 1.8 time = 480
* CHECK dout0_10 vdout0_10ck47 = 1.8 time = 480
* CHECK dout0_11 vdout0_11ck47 = 1.8 time = 480
* CHECK dout0_12 vdout0_12ck47 = 0 time = 480
* CHECK dout0_13 vdout0_13ck47 = 0 time = 480
* CHECK dout0_14 vdout0_14ck47 = 0 time = 480
* CHECK dout0_15 vdout0_15ck47 = 1.8 time = 480
* CHECK dout0_16 vdout0_16ck47 = 0 time = 480
* CHECK dout0_17 vdout0_17ck47 = 0 time = 480
* CHECK dout0_18 vdout0_18ck47 = 1.8 time = 480
* CHECK dout0_19 vdout0_19ck47 = 1.8 time = 480
* CHECK dout0_20 vdout0_20ck47 = 1.8 time = 480
* CHECK dout0_21 vdout0_21ck47 = 0 time = 480
* CHECK dout0_22 vdout0_22ck47 = 0 time = 480
* CHECK dout0_23 vdout0_23ck47 = 1.8 time = 480
* CHECK dout0_24 vdout0_24ck47 = 0 time = 480
* CHECK dout0_25 vdout0_25ck47 = 0 time = 480
* CHECK dout0_26 vdout0_26ck47 = 0 time = 480
* CHECK dout0_27 vdout0_27ck47 = 1.8 time = 480
* CHECK dout0_28 vdout0_28ck47 = 1.8 time = 480
* CHECK dout0_29 vdout0_29ck47 = 0 time = 480
* CHECK dout0_30 vdout0_30ck47 = 1.8 time = 480
* CHECK dout0_31 vdout0_31ck47 = 0 time = 480
* CHECK dout1_0 vdout1_0ck47 = 1.8 time = 480
* CHECK dout1_1 vdout1_1ck47 = 0 time = 480
* CHECK dout1_2 vdout1_2ck47 = 1.8 time = 480
* CHECK dout1_3 vdout1_3ck47 = 0 time = 480
* CHECK dout1_4 vdout1_4ck47 = 0 time = 480
* CHECK dout1_5 vdout1_5ck47 = 1.8 time = 480
* CHECK dout1_6 vdout1_6ck47 = 1.8 time = 480
* CHECK dout1_7 vdout1_7ck47 = 0 time = 480
* CHECK dout1_8 vdout1_8ck47 = 0 time = 480
* CHECK dout1_9 vdout1_9ck47 = 1.8 time = 480
* CHECK dout1_10 vdout1_10ck47 = 1.8 time = 480
* CHECK dout1_11 vdout1_11ck47 = 1.8 time = 480
* CHECK dout1_12 vdout1_12ck47 = 0 time = 480
* CHECK dout1_13 vdout1_13ck47 = 0 time = 480
* CHECK dout1_14 vdout1_14ck47 = 1.8 time = 480
* CHECK dout1_15 vdout1_15ck47 = 0 time = 480
* CHECK dout1_16 vdout1_16ck47 = 0 time = 480
* CHECK dout1_17 vdout1_17ck47 = 0 time = 480
* CHECK dout1_18 vdout1_18ck47 = 1.8 time = 480
* CHECK dout1_19 vdout1_19ck47 = 1.8 time = 480
* CHECK dout1_20 vdout1_20ck47 = 1.8 time = 480
* CHECK dout1_21 vdout1_21ck47 = 1.8 time = 480
* CHECK dout1_22 vdout1_22ck47 = 0 time = 480
* CHECK dout1_23 vdout1_23ck47 = 0 time = 480
* CHECK dout1_24 vdout1_24ck47 = 1.8 time = 480
* CHECK dout1_25 vdout1_25ck47 = 0 time = 480
* CHECK dout1_26 vdout1_26ck47 = 0 time = 480
* CHECK dout1_27 vdout1_27ck47 = 1.8 time = 480
* CHECK dout1_28 vdout1_28ck47 = 0 time = 480
* CHECK dout1_29 vdout1_29ck47 = 1.8 time = 480
* CHECK dout1_30 vdout1_30ck47 = 0 time = 480
* CHECK dout1_31 vdout1_31ck47 = 0 time = 480
* CHECK dout0_0 vdout0_0ck48 = 0 time = 490
* CHECK dout0_1 vdout0_1ck48 = 0 time = 490
* CHECK dout0_2 vdout0_2ck48 = 0 time = 490
* CHECK dout0_3 vdout0_3ck48 = 1.8 time = 490
* CHECK dout0_4 vdout0_4ck48 = 1.8 time = 490
* CHECK dout0_5 vdout0_5ck48 = 1.8 time = 490
* CHECK dout0_6 vdout0_6ck48 = 0 time = 490
* CHECK dout0_7 vdout0_7ck48 = 1.8 time = 490
* CHECK dout0_8 vdout0_8ck48 = 0 time = 490
* CHECK dout0_9 vdout0_9ck48 = 1.8 time = 490
* CHECK dout0_10 vdout0_10ck48 = 1.8 time = 490
* CHECK dout0_11 vdout0_11ck48 = 1.8 time = 490
* CHECK dout0_12 vdout0_12ck48 = 0 time = 490
* CHECK dout0_13 vdout0_13ck48 = 0 time = 490
* CHECK dout0_14 vdout0_14ck48 = 0 time = 490
* CHECK dout0_15 vdout0_15ck48 = 1.8 time = 490
* CHECK dout0_16 vdout0_16ck48 = 0 time = 490
* CHECK dout0_17 vdout0_17ck48 = 0 time = 490
* CHECK dout0_18 vdout0_18ck48 = 1.8 time = 490
* CHECK dout0_19 vdout0_19ck48 = 1.8 time = 490
* CHECK dout0_20 vdout0_20ck48 = 1.8 time = 490
* CHECK dout0_21 vdout0_21ck48 = 0 time = 490
* CHECK dout0_22 vdout0_22ck48 = 0 time = 490
* CHECK dout0_23 vdout0_23ck48 = 1.8 time = 490
* CHECK dout0_24 vdout0_24ck48 = 0 time = 490
* CHECK dout0_25 vdout0_25ck48 = 0 time = 490
* CHECK dout0_26 vdout0_26ck48 = 0 time = 490
* CHECK dout0_27 vdout0_27ck48 = 1.8 time = 490
* CHECK dout0_28 vdout0_28ck48 = 1.8 time = 490
* CHECK dout0_29 vdout0_29ck48 = 0 time = 490
* CHECK dout0_30 vdout0_30ck48 = 1.8 time = 490
* CHECK dout0_31 vdout0_31ck48 = 0 time = 490
* CHECK dout1_0 vdout1_0ck50 = 0 time = 510
* CHECK dout1_1 vdout1_1ck50 = 1.8 time = 510
* CHECK dout1_2 vdout1_2ck50 = 0 time = 510
* CHECK dout1_3 vdout1_3ck50 = 0 time = 510
* CHECK dout1_4 vdout1_4ck50 = 0 time = 510
* CHECK dout1_5 vdout1_5ck50 = 0 time = 510
* CHECK dout1_6 vdout1_6ck50 = 1.8 time = 510
* CHECK dout1_7 vdout1_7ck50 = 0 time = 510
* CHECK dout1_8 vdout1_8ck50 = 1.8 time = 510
* CHECK dout1_9 vdout1_9ck50 = 1.8 time = 510
* CHECK dout1_10 vdout1_10ck50 = 1.8 time = 510
* CHECK dout1_11 vdout1_11ck50 = 1.8 time = 510
* CHECK dout1_12 vdout1_12ck50 = 1.8 time = 510
* CHECK dout1_13 vdout1_13ck50 = 0 time = 510
* CHECK dout1_14 vdout1_14ck50 = 0 time = 510
* CHECK dout1_15 vdout1_15ck50 = 1.8 time = 510
* CHECK dout1_16 vdout1_16ck50 = 0 time = 510
* CHECK dout1_17 vdout1_17ck50 = 0 time = 510
* CHECK dout1_18 vdout1_18ck50 = 0 time = 510
* CHECK dout1_19 vdout1_19ck50 = 1.8 time = 510
* CHECK dout1_20 vdout1_20ck50 = 1.8 time = 510
* CHECK dout1_21 vdout1_21ck50 = 0 time = 510
* CHECK dout1_22 vdout1_22ck50 = 1.8 time = 510
* CHECK dout1_23 vdout1_23ck50 = 0 time = 510
* CHECK dout1_24 vdout1_24ck50 = 1.8 time = 510
* CHECK dout1_25 vdout1_25ck50 = 0 time = 510
* CHECK dout1_26 vdout1_26ck50 = 0 time = 510
* CHECK dout1_27 vdout1_27ck50 = 1.8 time = 510
* CHECK dout1_28 vdout1_28ck50 = 0 time = 510
* CHECK dout1_29 vdout1_29ck50 = 1.8 time = 510
* CHECK dout1_30 vdout1_30ck50 = 0 time = 510
* CHECK dout1_31 vdout1_31ck50 = 0 time = 510
* CHECK dout1_0 vdout1_0ck51 = 0 time = 520
* CHECK dout1_1 vdout1_1ck51 = 1.8 time = 520
* CHECK dout1_2 vdout1_2ck51 = 0 time = 520
* CHECK dout1_3 vdout1_3ck51 = 0 time = 520
* CHECK dout1_4 vdout1_4ck51 = 0 time = 520
* CHECK dout1_5 vdout1_5ck51 = 0 time = 520
* CHECK dout1_6 vdout1_6ck51 = 1.8 time = 520
* CHECK dout1_7 vdout1_7ck51 = 0 time = 520
* CHECK dout1_8 vdout1_8ck51 = 1.8 time = 520
* CHECK dout1_9 vdout1_9ck51 = 1.8 time = 520
* CHECK dout1_10 vdout1_10ck51 = 1.8 time = 520
* CHECK dout1_11 vdout1_11ck51 = 1.8 time = 520
* CHECK dout1_12 vdout1_12ck51 = 1.8 time = 520
* CHECK dout1_13 vdout1_13ck51 = 0 time = 520
* CHECK dout1_14 vdout1_14ck51 = 0 time = 520
* CHECK dout1_15 vdout1_15ck51 = 1.8 time = 520
* CHECK dout1_16 vdout1_16ck51 = 0 time = 520
* CHECK dout1_17 vdout1_17ck51 = 0 time = 520
* CHECK dout1_18 vdout1_18ck51 = 0 time = 520
* CHECK dout1_19 vdout1_19ck51 = 1.8 time = 520
* CHECK dout1_20 vdout1_20ck51 = 1.8 time = 520
* CHECK dout1_21 vdout1_21ck51 = 0 time = 520
* CHECK dout1_22 vdout1_22ck51 = 1.8 time = 520
* CHECK dout1_23 vdout1_23ck51 = 0 time = 520
* CHECK dout1_24 vdout1_24ck51 = 1.8 time = 520
* CHECK dout1_25 vdout1_25ck51 = 0 time = 520
* CHECK dout1_26 vdout1_26ck51 = 0 time = 520
* CHECK dout1_27 vdout1_27ck51 = 1.8 time = 520
* CHECK dout1_28 vdout1_28ck51 = 0 time = 520
* CHECK dout1_29 vdout1_29ck51 = 1.8 time = 520
* CHECK dout1_30 vdout1_30ck51 = 0 time = 520
* CHECK dout1_31 vdout1_31ck51 = 0 time = 520
* CHECK dout1_0 vdout1_0ck53 = 0 time = 540
* CHECK dout1_1 vdout1_1ck53 = 1.8 time = 540
* CHECK dout1_2 vdout1_2ck53 = 1.8 time = 540
* CHECK dout1_3 vdout1_3ck53 = 1.8 time = 540
* CHECK dout1_4 vdout1_4ck53 = 0 time = 540
* CHECK dout1_5 vdout1_5ck53 = 0 time = 540
* CHECK dout1_6 vdout1_6ck53 = 1.8 time = 540
* CHECK dout1_7 vdout1_7ck53 = 1.8 time = 540
* CHECK dout1_8 vdout1_8ck53 = 1.8 time = 540
* CHECK dout1_9 vdout1_9ck53 = 1.8 time = 540
* CHECK dout1_10 vdout1_10ck53 = 1.8 time = 540
* CHECK dout1_11 vdout1_11ck53 = 0 time = 540
* CHECK dout1_12 vdout1_12ck53 = 1.8 time = 540
* CHECK dout1_13 vdout1_13ck53 = 0 time = 540
* CHECK dout1_14 vdout1_14ck53 = 1.8 time = 540
* CHECK dout1_15 vdout1_15ck53 = 0 time = 540
* CHECK dout1_16 vdout1_16ck53 = 0 time = 540
* CHECK dout1_17 vdout1_17ck53 = 0 time = 540
* CHECK dout1_18 vdout1_18ck53 = 0 time = 540
* CHECK dout1_19 vdout1_19ck53 = 1.8 time = 540
* CHECK dout1_20 vdout1_20ck53 = 1.8 time = 540
* CHECK dout1_21 vdout1_21ck53 = 1.8 time = 540
* CHECK dout1_22 vdout1_22ck53 = 1.8 time = 540
* CHECK dout1_23 vdout1_23ck53 = 1.8 time = 540
* CHECK dout1_24 vdout1_24ck53 = 0 time = 540
* CHECK dout1_25 vdout1_25ck53 = 0 time = 540
* CHECK dout1_26 vdout1_26ck53 = 1.8 time = 540
* CHECK dout1_27 vdout1_27ck53 = 1.8 time = 540
* CHECK dout1_28 vdout1_28ck53 = 0 time = 540
* CHECK dout1_29 vdout1_29ck53 = 0 time = 540
* CHECK dout1_30 vdout1_30ck53 = 1.8 time = 540
* CHECK dout1_31 vdout1_31ck53 = 0 time = 540
* CHECK dout0_0 vdout0_0ck56 = 0 time = 570
* CHECK dout0_1 vdout0_1ck56 = 1.8 time = 570
* CHECK dout0_2 vdout0_2ck56 = 1.8 time = 570
* CHECK dout0_3 vdout0_3ck56 = 1.8 time = 570
* CHECK dout0_4 vdout0_4ck56 = 0 time = 570
* CHECK dout0_5 vdout0_5ck56 = 0 time = 570
* CHECK dout0_6 vdout0_6ck56 = 1.8 time = 570
* CHECK dout0_7 vdout0_7ck56 = 1.8 time = 570
* CHECK dout0_8 vdout0_8ck56 = 1.8 time = 570
* CHECK dout0_9 vdout0_9ck56 = 1.8 time = 570
* CHECK dout0_10 vdout0_10ck56 = 1.8 time = 570
* CHECK dout0_11 vdout0_11ck56 = 0 time = 570
* CHECK dout0_12 vdout0_12ck56 = 1.8 time = 570
* CHECK dout0_13 vdout0_13ck56 = 0 time = 570
* CHECK dout0_14 vdout0_14ck56 = 1.8 time = 570
* CHECK dout0_15 vdout0_15ck56 = 0 time = 570
* CHECK dout0_16 vdout0_16ck56 = 0 time = 570
* CHECK dout0_17 vdout0_17ck56 = 0 time = 570
* CHECK dout0_18 vdout0_18ck56 = 0 time = 570
* CHECK dout0_19 vdout0_19ck56 = 1.8 time = 570
* CHECK dout0_20 vdout0_20ck56 = 1.8 time = 570
* CHECK dout0_21 vdout0_21ck56 = 1.8 time = 570
* CHECK dout0_22 vdout0_22ck56 = 1.8 time = 570
* CHECK dout0_23 vdout0_23ck56 = 1.8 time = 570
* CHECK dout0_24 vdout0_24ck56 = 0 time = 570
* CHECK dout0_25 vdout0_25ck56 = 0 time = 570
* CHECK dout0_26 vdout0_26ck56 = 1.8 time = 570
* CHECK dout0_27 vdout0_27ck56 = 1.8 time = 570
* CHECK dout0_28 vdout0_28ck56 = 0 time = 570
* CHECK dout0_29 vdout0_29ck56 = 0 time = 570
* CHECK dout0_30 vdout0_30ck56 = 1.8 time = 570
* CHECK dout0_31 vdout0_31ck56 = 0 time = 570
* CHECK dout1_0 vdout1_0ck56 = 0 time = 570
* CHECK dout1_1 vdout1_1ck56 = 1.8 time = 570
* CHECK dout1_2 vdout1_2ck56 = 1.8 time = 570
* CHECK dout1_3 vdout1_3ck56 = 1.8 time = 570
* CHECK dout1_4 vdout1_4ck56 = 0 time = 570
* CHECK dout1_5 vdout1_5ck56 = 0 time = 570
* CHECK dout1_6 vdout1_6ck56 = 1.8 time = 570
* CHECK dout1_7 vdout1_7ck56 = 1.8 time = 570
* CHECK dout1_8 vdout1_8ck56 = 1.8 time = 570
* CHECK dout1_9 vdout1_9ck56 = 1.8 time = 570
* CHECK dout1_10 vdout1_10ck56 = 1.8 time = 570
* CHECK dout1_11 vdout1_11ck56 = 0 time = 570
* CHECK dout1_12 vdout1_12ck56 = 1.8 time = 570
* CHECK dout1_13 vdout1_13ck56 = 0 time = 570
* CHECK dout1_14 vdout1_14ck56 = 1.8 time = 570
* CHECK dout1_15 vdout1_15ck56 = 0 time = 570
* CHECK dout1_16 vdout1_16ck56 = 0 time = 570
* CHECK dout1_17 vdout1_17ck56 = 0 time = 570
* CHECK dout1_18 vdout1_18ck56 = 0 time = 570
* CHECK dout1_19 vdout1_19ck56 = 1.8 time = 570
* CHECK dout1_20 vdout1_20ck56 = 1.8 time = 570
* CHECK dout1_21 vdout1_21ck56 = 1.8 time = 570
* CHECK dout1_22 vdout1_22ck56 = 1.8 time = 570
* CHECK dout1_23 vdout1_23ck56 = 1.8 time = 570
* CHECK dout1_24 vdout1_24ck56 = 0 time = 570
* CHECK dout1_25 vdout1_25ck56 = 0 time = 570
* CHECK dout1_26 vdout1_26ck56 = 1.8 time = 570
* CHECK dout1_27 vdout1_27ck56 = 1.8 time = 570
* CHECK dout1_28 vdout1_28ck56 = 0 time = 570
* CHECK dout1_29 vdout1_29ck56 = 0 time = 570
* CHECK dout1_30 vdout1_30ck56 = 1.8 time = 570
* CHECK dout1_31 vdout1_31ck56 = 0 time = 570
* CHECK dout0_0 vdout0_0ck57 = 1.8 time = 580
* CHECK dout0_1 vdout0_1ck57 = 0 time = 580
* CHECK dout0_2 vdout0_2ck57 = 1.8 time = 580
* CHECK dout0_3 vdout0_3ck57 = 1.8 time = 580
* CHECK dout0_4 vdout0_4ck57 = 0 time = 580
* CHECK dout0_5 vdout0_5ck57 = 0 time = 580
* CHECK dout0_6 vdout0_6ck57 = 0 time = 580
* CHECK dout0_7 vdout0_7ck57 = 0 time = 580
* CHECK dout0_8 vdout0_8ck57 = 0 time = 580
* CHECK dout0_9 vdout0_9ck57 = 0 time = 580
* CHECK dout0_10 vdout0_10ck57 = 0 time = 580
* CHECK dout0_11 vdout0_11ck57 = 1.8 time = 580
* CHECK dout0_12 vdout0_12ck57 = 0 time = 580
* CHECK dout0_13 vdout0_13ck57 = 0 time = 580
* CHECK dout0_14 vdout0_14ck57 = 0 time = 580
* CHECK dout0_15 vdout0_15ck57 = 0 time = 580
* CHECK dout0_16 vdout0_16ck57 = 0 time = 580
* CHECK dout0_17 vdout0_17ck57 = 1.8 time = 580
* CHECK dout0_18 vdout0_18ck57 = 0 time = 580
* CHECK dout0_19 vdout0_19ck57 = 1.8 time = 580
* CHECK dout0_20 vdout0_20ck57 = 0 time = 580
* CHECK dout0_21 vdout0_21ck57 = 1.8 time = 580
* CHECK dout0_22 vdout0_22ck57 = 0 time = 580
* CHECK dout0_23 vdout0_23ck57 = 1.8 time = 580
* CHECK dout0_24 vdout0_24ck57 = 0 time = 580
* CHECK dout0_25 vdout0_25ck57 = 0 time = 580
* CHECK dout0_26 vdout0_26ck57 = 0 time = 580
* CHECK dout0_27 vdout0_27ck57 = 0 time = 580
* CHECK dout0_28 vdout0_28ck57 = 0 time = 580
* CHECK dout0_29 vdout0_29ck57 = 1.8 time = 580
* CHECK dout0_30 vdout0_30ck57 = 0 time = 580
* CHECK dout0_31 vdout0_31ck57 = 0 time = 580
* CHECK dout1_0 vdout1_0ck57 = 1.8 time = 580
* CHECK dout1_1 vdout1_1ck57 = 0 time = 580
* CHECK dout1_2 vdout1_2ck57 = 0 time = 580
* CHECK dout1_3 vdout1_3ck57 = 0 time = 580
* CHECK dout1_4 vdout1_4ck57 = 1.8 time = 580
* CHECK dout1_5 vdout1_5ck57 = 1.8 time = 580
* CHECK dout1_6 vdout1_6ck57 = 1.8 time = 580
* CHECK dout1_7 vdout1_7ck57 = 1.8 time = 580
* CHECK dout1_8 vdout1_8ck57 = 1.8 time = 580
* CHECK dout1_9 vdout1_9ck57 = 0 time = 580
* CHECK dout1_10 vdout1_10ck57 = 0 time = 580
* CHECK dout1_11 vdout1_11ck57 = 1.8 time = 580
* CHECK dout1_12 vdout1_12ck57 = 1.8 time = 580
* CHECK dout1_13 vdout1_13ck57 = 1.8 time = 580
* CHECK dout1_14 vdout1_14ck57 = 0 time = 580
* CHECK dout1_15 vdout1_15ck57 = 1.8 time = 580
* CHECK dout1_16 vdout1_16ck57 = 0 time = 580
* CHECK dout1_17 vdout1_17ck57 = 1.8 time = 580
* CHECK dout1_18 vdout1_18ck57 = 0 time = 580
* CHECK dout1_19 vdout1_19ck57 = 0 time = 580
* CHECK dout1_20 vdout1_20ck57 = 0 time = 580
* CHECK dout1_21 vdout1_21ck57 = 1.8 time = 580
* CHECK dout1_22 vdout1_22ck57 = 1.8 time = 580
* CHECK dout1_23 vdout1_23ck57 = 0 time = 580
* CHECK dout1_24 vdout1_24ck57 = 0 time = 580
* CHECK dout1_25 vdout1_25ck57 = 1.8 time = 580
* CHECK dout1_26 vdout1_26ck57 = 0 time = 580
* CHECK dout1_27 vdout1_27ck57 = 1.8 time = 580
* CHECK dout1_28 vdout1_28ck57 = 0 time = 580
* CHECK dout1_29 vdout1_29ck57 = 1.8 time = 580
* CHECK dout1_30 vdout1_30ck57 = 0 time = 580
* CHECK dout1_31 vdout1_31ck57 = 0 time = 580
* CHECK dout1_0 vdout1_0ck58 = 1.8 time = 590
* CHECK dout1_1 vdout1_1ck58 = 1.8 time = 590
* CHECK dout1_2 vdout1_2ck58 = 0 time = 590
* CHECK dout1_3 vdout1_3ck58 = 1.8 time = 590
* CHECK dout1_4 vdout1_4ck58 = 0 time = 590
* CHECK dout1_5 vdout1_5ck58 = 1.8 time = 590
* CHECK dout1_6 vdout1_6ck58 = 1.8 time = 590
* CHECK dout1_7 vdout1_7ck58 = 0 time = 590
* CHECK dout1_8 vdout1_8ck58 = 1.8 time = 590
* CHECK dout1_9 vdout1_9ck58 = 0 time = 590
* CHECK dout1_10 vdout1_10ck58 = 1.8 time = 590
* CHECK dout1_11 vdout1_11ck58 = 1.8 time = 590
* CHECK dout1_12 vdout1_12ck58 = 1.8 time = 590
* CHECK dout1_13 vdout1_13ck58 = 1.8 time = 590
* CHECK dout1_14 vdout1_14ck58 = 0 time = 590
* CHECK dout1_15 vdout1_15ck58 = 1.8 time = 590
* CHECK dout1_16 vdout1_16ck58 = 1.8 time = 590
* CHECK dout1_17 vdout1_17ck58 = 1.8 time = 590
* CHECK dout1_18 vdout1_18ck58 = 0 time = 590
* CHECK dout1_19 vdout1_19ck58 = 1.8 time = 590
* CHECK dout1_20 vdout1_20ck58 = 1.8 time = 590
* CHECK dout1_21 vdout1_21ck58 = 0 time = 590
* CHECK dout1_22 vdout1_22ck58 = 0 time = 590
* CHECK dout1_23 vdout1_23ck58 = 1.8 time = 590
* CHECK dout1_24 vdout1_24ck58 = 0 time = 590
* CHECK dout1_25 vdout1_25ck58 = 0 time = 590
* CHECK dout1_26 vdout1_26ck58 = 1.8 time = 590
* CHECK dout1_27 vdout1_27ck58 = 1.8 time = 590
* CHECK dout1_28 vdout1_28ck58 = 0 time = 590
* CHECK dout1_29 vdout1_29ck58 = 1.8 time = 590
* CHECK dout1_30 vdout1_30ck58 = 1.8 time = 590
* CHECK dout1_31 vdout1_31ck58 = 1.8 time = 590
* CHECK dout0_0 vdout0_0ck60 = 0 time = 610
* CHECK dout0_1 vdout0_1ck60 = 0 time = 610
* CHECK dout0_2 vdout0_2ck60 = 1.8 time = 610
* CHECK dout0_3 vdout0_3ck60 = 0 time = 610
* CHECK dout0_4 vdout0_4ck60 = 0 time = 610
* CHECK dout0_5 vdout0_5ck60 = 0 time = 610
* CHECK dout0_6 vdout0_6ck60 = 1.8 time = 610
* CHECK dout0_7 vdout0_7ck60 = 0 time = 610
* CHECK dout0_8 vdout0_8ck60 = 1.8 time = 610
* CHECK dout0_9 vdout0_9ck60 = 1.8 time = 610
* CHECK dout0_10 vdout0_10ck60 = 1.8 time = 610
* CHECK dout0_11 vdout0_11ck60 = 0 time = 610
* CHECK dout0_12 vdout0_12ck60 = 1.8 time = 610
* CHECK dout0_13 vdout0_13ck60 = 0 time = 610
* CHECK dout0_14 vdout0_14ck60 = 1.8 time = 610
* CHECK dout0_15 vdout0_15ck60 = 0 time = 610
* CHECK dout0_16 vdout0_16ck60 = 0 time = 610
* CHECK dout0_17 vdout0_17ck60 = 1.8 time = 610
* CHECK dout0_18 vdout0_18ck60 = 0 time = 610
* CHECK dout0_19 vdout0_19ck60 = 1.8 time = 610
* CHECK dout0_20 vdout0_20ck60 = 0 time = 610
* CHECK dout0_21 vdout0_21ck60 = 1.8 time = 610
* CHECK dout0_22 vdout0_22ck60 = 0 time = 610
* CHECK dout0_23 vdout0_23ck60 = 0 time = 610
* CHECK dout0_24 vdout0_24ck60 = 1.8 time = 610
* CHECK dout0_25 vdout0_25ck60 = 0 time = 610
* CHECK dout0_26 vdout0_26ck60 = 0 time = 610
* CHECK dout0_27 vdout0_27ck60 = 0 time = 610
* CHECK dout0_28 vdout0_28ck60 = 1.8 time = 610
* CHECK dout0_29 vdout0_29ck60 = 1.8 time = 610
* CHECK dout0_30 vdout0_30ck60 = 1.8 time = 610
* CHECK dout0_31 vdout0_31ck60 = 1.8 time = 610
* CHECK dout1_0 vdout1_0ck60 = 0 time = 610
* CHECK dout1_1 vdout1_1ck60 = 1.8 time = 610
* CHECK dout1_2 vdout1_2ck60 = 1.8 time = 610
* CHECK dout1_3 vdout1_3ck60 = 1.8 time = 610
* CHECK dout1_4 vdout1_4ck60 = 0 time = 610
* CHECK dout1_5 vdout1_5ck60 = 0 time = 610
* CHECK dout1_6 vdout1_6ck60 = 1.8 time = 610
* CHECK dout1_7 vdout1_7ck60 = 1.8 time = 610
* CHECK dout1_8 vdout1_8ck60 = 1.8 time = 610
* CHECK dout1_9 vdout1_9ck60 = 1.8 time = 610
* CHECK dout1_10 vdout1_10ck60 = 1.8 time = 610
* CHECK dout1_11 vdout1_11ck60 = 0 time = 610
* CHECK dout1_12 vdout1_12ck60 = 1.8 time = 610
* CHECK dout1_13 vdout1_13ck60 = 0 time = 610
* CHECK dout1_14 vdout1_14ck60 = 1.8 time = 610
* CHECK dout1_15 vdout1_15ck60 = 0 time = 610
* CHECK dout1_16 vdout1_16ck60 = 0 time = 610
* CHECK dout1_17 vdout1_17ck60 = 0 time = 610
* CHECK dout1_18 vdout1_18ck60 = 0 time = 610
* CHECK dout1_19 vdout1_19ck60 = 1.8 time = 610
* CHECK dout1_20 vdout1_20ck60 = 1.8 time = 610
* CHECK dout1_21 vdout1_21ck60 = 1.8 time = 610
* CHECK dout1_22 vdout1_22ck60 = 1.8 time = 610
* CHECK dout1_23 vdout1_23ck60 = 1.8 time = 610
* CHECK dout1_24 vdout1_24ck60 = 0 time = 610
* CHECK dout1_25 vdout1_25ck60 = 0 time = 610
* CHECK dout1_26 vdout1_26ck60 = 1.8 time = 610
* CHECK dout1_27 vdout1_27ck60 = 1.8 time = 610
* CHECK dout1_28 vdout1_28ck60 = 0 time = 610
* CHECK dout1_29 vdout1_29ck60 = 0 time = 610
* CHECK dout1_30 vdout1_30ck60 = 1.8 time = 610
* CHECK dout1_31 vdout1_31ck60 = 0 time = 610
* CHECK dout0_0 vdout0_0ck61 = 1.8 time = 620
* CHECK dout0_1 vdout0_1ck61 = 1.8 time = 620
* CHECK dout0_2 vdout0_2ck61 = 0 time = 620
* CHECK dout0_3 vdout0_3ck61 = 1.8 time = 620
* CHECK dout0_4 vdout0_4ck61 = 0 time = 620
* CHECK dout0_5 vdout0_5ck61 = 1.8 time = 620
* CHECK dout0_6 vdout0_6ck61 = 1.8 time = 620
* CHECK dout0_7 vdout0_7ck61 = 0 time = 620
* CHECK dout0_8 vdout0_8ck61 = 1.8 time = 620
* CHECK dout0_9 vdout0_9ck61 = 0 time = 620
* CHECK dout0_10 vdout0_10ck61 = 1.8 time = 620
* CHECK dout0_11 vdout0_11ck61 = 1.8 time = 620
* CHECK dout0_12 vdout0_12ck61 = 1.8 time = 620
* CHECK dout0_13 vdout0_13ck61 = 1.8 time = 620
* CHECK dout0_14 vdout0_14ck61 = 0 time = 620
* CHECK dout0_15 vdout0_15ck61 = 1.8 time = 620
* CHECK dout0_16 vdout0_16ck61 = 1.8 time = 620
* CHECK dout0_17 vdout0_17ck61 = 1.8 time = 620
* CHECK dout0_18 vdout0_18ck61 = 0 time = 620
* CHECK dout0_19 vdout0_19ck61 = 1.8 time = 620
* CHECK dout0_20 vdout0_20ck61 = 1.8 time = 620
* CHECK dout0_21 vdout0_21ck61 = 0 time = 620
* CHECK dout0_22 vdout0_22ck61 = 0 time = 620
* CHECK dout0_23 vdout0_23ck61 = 1.8 time = 620
* CHECK dout0_24 vdout0_24ck61 = 0 time = 620
* CHECK dout0_25 vdout0_25ck61 = 0 time = 620
* CHECK dout0_26 vdout0_26ck61 = 1.8 time = 620
* CHECK dout0_27 vdout0_27ck61 = 1.8 time = 620
* CHECK dout0_28 vdout0_28ck61 = 0 time = 620
* CHECK dout0_29 vdout0_29ck61 = 1.8 time = 620
* CHECK dout0_30 vdout0_30ck61 = 1.8 time = 620
* CHECK dout0_31 vdout0_31ck61 = 1.8 time = 620
* CHECK dout0_0 vdout0_0ck62 = 0 time = 630
* CHECK dout0_1 vdout0_1ck62 = 1.8 time = 630
* CHECK dout0_2 vdout0_2ck62 = 1.8 time = 630
* CHECK dout0_3 vdout0_3ck62 = 1.8 time = 630
* CHECK dout0_4 vdout0_4ck62 = 0 time = 630
* CHECK dout0_5 vdout0_5ck62 = 0 time = 630
* CHECK dout0_6 vdout0_6ck62 = 1.8 time = 630
* CHECK dout0_7 vdout0_7ck62 = 1.8 time = 630
* CHECK dout0_8 vdout0_8ck62 = 1.8 time = 630
* CHECK dout0_9 vdout0_9ck62 = 1.8 time = 630
* CHECK dout0_10 vdout0_10ck62 = 1.8 time = 630
* CHECK dout0_11 vdout0_11ck62 = 0 time = 630
* CHECK dout0_12 vdout0_12ck62 = 1.8 time = 630
* CHECK dout0_13 vdout0_13ck62 = 0 time = 630
* CHECK dout0_14 vdout0_14ck62 = 1.8 time = 630
* CHECK dout0_15 vdout0_15ck62 = 0 time = 630
* CHECK dout0_16 vdout0_16ck62 = 0 time = 630
* CHECK dout0_17 vdout0_17ck62 = 0 time = 630
* CHECK dout0_18 vdout0_18ck62 = 0 time = 630
* CHECK dout0_19 vdout0_19ck62 = 1.8 time = 630
* CHECK dout0_20 vdout0_20ck62 = 1.8 time = 630
* CHECK dout0_21 vdout0_21ck62 = 1.8 time = 630
* CHECK dout0_22 vdout0_22ck62 = 1.8 time = 630
* CHECK dout0_23 vdout0_23ck62 = 1.8 time = 630
* CHECK dout0_24 vdout0_24ck62 = 0 time = 630
* CHECK dout0_25 vdout0_25ck62 = 0 time = 630
* CHECK dout0_26 vdout0_26ck62 = 1.8 time = 630
* CHECK dout0_27 vdout0_27ck62 = 1.8 time = 630
* CHECK dout0_28 vdout0_28ck62 = 0 time = 630
* CHECK dout0_29 vdout0_29ck62 = 0 time = 630
* CHECK dout0_30 vdout0_30ck62 = 1.8 time = 630
* CHECK dout0_31 vdout0_31ck62 = 0 time = 630
* CHECK dout0_0 vdout0_0ck65 = 1.8 time = 660
* CHECK dout0_1 vdout0_1ck65 = 0 time = 660
* CHECK dout0_2 vdout0_2ck65 = 0 time = 660
* CHECK dout0_3 vdout0_3ck65 = 0 time = 660
* CHECK dout0_4 vdout0_4ck65 = 1.8 time = 660
* CHECK dout0_5 vdout0_5ck65 = 0 time = 660
* CHECK dout0_6 vdout0_6ck65 = 0 time = 660
* CHECK dout0_7 vdout0_7ck65 = 0 time = 660
* CHECK dout0_8 vdout0_8ck65 = 0 time = 660
* CHECK dout0_9 vdout0_9ck65 = 1.8 time = 660
* CHECK dout0_10 vdout0_10ck65 = 0 time = 660
* CHECK dout0_11 vdout0_11ck65 = 0 time = 660
* CHECK dout0_12 vdout0_12ck65 = 1.8 time = 660
* CHECK dout0_13 vdout0_13ck65 = 1.8 time = 660
* CHECK dout0_14 vdout0_14ck65 = 0 time = 660
* CHECK dout0_15 vdout0_15ck65 = 1.8 time = 660
* CHECK dout0_16 vdout0_16ck65 = 0 time = 660
* CHECK dout0_17 vdout0_17ck65 = 1.8 time = 660
* CHECK dout0_18 vdout0_18ck65 = 1.8 time = 660
* CHECK dout0_19 vdout0_19ck65 = 0 time = 660
* CHECK dout0_20 vdout0_20ck65 = 1.8 time = 660
* CHECK dout0_21 vdout0_21ck65 = 0 time = 660
* CHECK dout0_22 vdout0_22ck65 = 1.8 time = 660
* CHECK dout0_23 vdout0_23ck65 = 1.8 time = 660
* CHECK dout0_24 vdout0_24ck65 = 0 time = 660
* CHECK dout0_25 vdout0_25ck65 = 0 time = 660
* CHECK dout0_26 vdout0_26ck65 = 0 time = 660
* CHECK dout0_27 vdout0_27ck65 = 1.8 time = 660
* CHECK dout0_28 vdout0_28ck65 = 1.8 time = 660
* CHECK dout0_29 vdout0_29ck65 = 0 time = 660
* CHECK dout0_30 vdout0_30ck65 = 0 time = 660
* CHECK dout0_31 vdout0_31ck65 = 1.8 time = 660
* CHECK dout0_0 vdout0_0ck68 = 0 time = 690
* CHECK dout0_1 vdout0_1ck68 = 0 time = 690
* CHECK dout0_2 vdout0_2ck68 = 1.8 time = 690
* CHECK dout0_3 vdout0_3ck68 = 0 time = 690
* CHECK dout0_4 vdout0_4ck68 = 0 time = 690
* CHECK dout0_5 vdout0_5ck68 = 0 time = 690
* CHECK dout0_6 vdout0_6ck68 = 1.8 time = 690
* CHECK dout0_7 vdout0_7ck68 = 0 time = 690
* CHECK dout0_8 vdout0_8ck68 = 1.8 time = 690
* CHECK dout0_9 vdout0_9ck68 = 1.8 time = 690
* CHECK dout0_10 vdout0_10ck68 = 1.8 time = 690
* CHECK dout0_11 vdout0_11ck68 = 0 time = 690
* CHECK dout0_12 vdout0_12ck68 = 1.8 time = 690
* CHECK dout0_13 vdout0_13ck68 = 0 time = 690
* CHECK dout0_14 vdout0_14ck68 = 1.8 time = 690
* CHECK dout0_15 vdout0_15ck68 = 0 time = 690
* CHECK dout0_16 vdout0_16ck68 = 0 time = 690
* CHECK dout0_17 vdout0_17ck68 = 1.8 time = 690
* CHECK dout0_18 vdout0_18ck68 = 0 time = 690
* CHECK dout0_19 vdout0_19ck68 = 1.8 time = 690
* CHECK dout0_20 vdout0_20ck68 = 0 time = 690
* CHECK dout0_21 vdout0_21ck68 = 1.8 time = 690
* CHECK dout0_22 vdout0_22ck68 = 0 time = 690
* CHECK dout0_23 vdout0_23ck68 = 0 time = 690
* CHECK dout0_24 vdout0_24ck68 = 1.8 time = 690
* CHECK dout0_25 vdout0_25ck68 = 0 time = 690
* CHECK dout0_26 vdout0_26ck68 = 0 time = 690
* CHECK dout0_27 vdout0_27ck68 = 0 time = 690
* CHECK dout0_28 vdout0_28ck68 = 1.8 time = 690
* CHECK dout0_29 vdout0_29ck68 = 1.8 time = 690
* CHECK dout0_30 vdout0_30ck68 = 1.8 time = 690
* CHECK dout0_31 vdout0_31ck68 = 1.8 time = 690
* CHECK dout0_0 vdout0_0ck69 = 0 time = 700
* CHECK dout0_1 vdout0_1ck69 = 0 time = 700
* CHECK dout0_2 vdout0_2ck69 = 1.8 time = 700
* CHECK dout0_3 vdout0_3ck69 = 0 time = 700
* CHECK dout0_4 vdout0_4ck69 = 0 time = 700
* CHECK dout0_5 vdout0_5ck69 = 0 time = 700
* CHECK dout0_6 vdout0_6ck69 = 1.8 time = 700
* CHECK dout0_7 vdout0_7ck69 = 0 time = 700
* CHECK dout0_8 vdout0_8ck69 = 1.8 time = 700
* CHECK dout0_9 vdout0_9ck69 = 1.8 time = 700
* CHECK dout0_10 vdout0_10ck69 = 1.8 time = 700
* CHECK dout0_11 vdout0_11ck69 = 0 time = 700
* CHECK dout0_12 vdout0_12ck69 = 1.8 time = 700
* CHECK dout0_13 vdout0_13ck69 = 0 time = 700
* CHECK dout0_14 vdout0_14ck69 = 1.8 time = 700
* CHECK dout0_15 vdout0_15ck69 = 0 time = 700
* CHECK dout0_16 vdout0_16ck69 = 0 time = 700
* CHECK dout0_17 vdout0_17ck69 = 1.8 time = 700
* CHECK dout0_18 vdout0_18ck69 = 0 time = 700
* CHECK dout0_19 vdout0_19ck69 = 1.8 time = 700
* CHECK dout0_20 vdout0_20ck69 = 0 time = 700
* CHECK dout0_21 vdout0_21ck69 = 1.8 time = 700
* CHECK dout0_22 vdout0_22ck69 = 0 time = 700
* CHECK dout0_23 vdout0_23ck69 = 0 time = 700
* CHECK dout0_24 vdout0_24ck69 = 1.8 time = 700
* CHECK dout0_25 vdout0_25ck69 = 0 time = 700
* CHECK dout0_26 vdout0_26ck69 = 0 time = 700
* CHECK dout0_27 vdout0_27ck69 = 0 time = 700
* CHECK dout0_28 vdout0_28ck69 = 1.8 time = 700
* CHECK dout0_29 vdout0_29ck69 = 1.8 time = 700
* CHECK dout0_30 vdout0_30ck69 = 1.8 time = 700
* CHECK dout0_31 vdout0_31ck69 = 1.8 time = 700
* CHECK dout1_0 vdout1_0ck69 = 0 time = 700
* CHECK dout1_1 vdout1_1ck69 = 1.8 time = 700
* CHECK dout1_2 vdout1_2ck69 = 0 time = 700
* CHECK dout1_3 vdout1_3ck69 = 0 time = 700
* CHECK dout1_4 vdout1_4ck69 = 0 time = 700
* CHECK dout1_5 vdout1_5ck69 = 0 time = 700
* CHECK dout1_6 vdout1_6ck69 = 1.8 time = 700
* CHECK dout1_7 vdout1_7ck69 = 0 time = 700
* CHECK dout1_8 vdout1_8ck69 = 1.8 time = 700
* CHECK dout1_9 vdout1_9ck69 = 1.8 time = 700
* CHECK dout1_10 vdout1_10ck69 = 1.8 time = 700
* CHECK dout1_11 vdout1_11ck69 = 1.8 time = 700
* CHECK dout1_12 vdout1_12ck69 = 1.8 time = 700
* CHECK dout1_13 vdout1_13ck69 = 0 time = 700
* CHECK dout1_14 vdout1_14ck69 = 0 time = 700
* CHECK dout1_15 vdout1_15ck69 = 1.8 time = 700
* CHECK dout1_16 vdout1_16ck69 = 0 time = 700
* CHECK dout1_17 vdout1_17ck69 = 0 time = 700
* CHECK dout1_18 vdout1_18ck69 = 0 time = 700
* CHECK dout1_19 vdout1_19ck69 = 1.8 time = 700
* CHECK dout1_20 vdout1_20ck69 = 1.8 time = 700
* CHECK dout1_21 vdout1_21ck69 = 0 time = 700
* CHECK dout1_22 vdout1_22ck69 = 1.8 time = 700
* CHECK dout1_23 vdout1_23ck69 = 0 time = 700
* CHECK dout1_24 vdout1_24ck69 = 1.8 time = 700
* CHECK dout1_25 vdout1_25ck69 = 0 time = 700
* CHECK dout1_26 vdout1_26ck69 = 0 time = 700
* CHECK dout1_27 vdout1_27ck69 = 1.8 time = 700
* CHECK dout1_28 vdout1_28ck69 = 0 time = 700
* CHECK dout1_29 vdout1_29ck69 = 1.8 time = 700
* CHECK dout1_30 vdout1_30ck69 = 0 time = 700
* CHECK dout1_31 vdout1_31ck69 = 0 time = 700
* CHECK dout0_0 vdout0_0ck75 = 0 time = 760
* CHECK dout0_1 vdout0_1ck75 = 1.8 time = 760
* CHECK dout0_2 vdout0_2ck75 = 1.8 time = 760
* CHECK dout0_3 vdout0_3ck75 = 0 time = 760
* CHECK dout0_4 vdout0_4ck75 = 1.8 time = 760
* CHECK dout0_5 vdout0_5ck75 = 1.8 time = 760
* CHECK dout0_6 vdout0_6ck75 = 1.8 time = 760
* CHECK dout0_7 vdout0_7ck75 = 1.8 time = 760
* CHECK dout0_8 vdout0_8ck75 = 1.8 time = 760
* CHECK dout0_9 vdout0_9ck75 = 0 time = 760
* CHECK dout0_10 vdout0_10ck75 = 0 time = 760
* CHECK dout0_11 vdout0_11ck75 = 1.8 time = 760
* CHECK dout0_12 vdout0_12ck75 = 0 time = 760
* CHECK dout0_13 vdout0_13ck75 = 0 time = 760
* CHECK dout0_14 vdout0_14ck75 = 1.8 time = 760
* CHECK dout0_15 vdout0_15ck75 = 1.8 time = 760
* CHECK dout0_16 vdout0_16ck75 = 0 time = 760
* CHECK dout0_17 vdout0_17ck75 = 1.8 time = 760
* CHECK dout0_18 vdout0_18ck75 = 0 time = 760
* CHECK dout0_19 vdout0_19ck75 = 1.8 time = 760
* CHECK dout0_20 vdout0_20ck75 = 0 time = 760
* CHECK dout0_21 vdout0_21ck75 = 1.8 time = 760
* CHECK dout0_22 vdout0_22ck75 = 0 time = 760
* CHECK dout0_23 vdout0_23ck75 = 0 time = 760
* CHECK dout0_24 vdout0_24ck75 = 0 time = 760
* CHECK dout0_25 vdout0_25ck75 = 0 time = 760
* CHECK dout0_26 vdout0_26ck75 = 0 time = 760
* CHECK dout0_27 vdout0_27ck75 = 0 time = 760
* CHECK dout0_28 vdout0_28ck75 = 0 time = 760
* CHECK dout0_29 vdout0_29ck75 = 0 time = 760
* CHECK dout0_30 vdout0_30ck75 = 1.8 time = 760
* CHECK dout0_31 vdout0_31ck75 = 0 time = 760
* CHECK dout1_0 vdout1_0ck77 = 1.8 time = 780
* CHECK dout1_1 vdout1_1ck77 = 1.8 time = 780
* CHECK dout1_2 vdout1_2ck77 = 0 time = 780
* CHECK dout1_3 vdout1_3ck77 = 1.8 time = 780
* CHECK dout1_4 vdout1_4ck77 = 0 time = 780
* CHECK dout1_5 vdout1_5ck77 = 1.8 time = 780
* CHECK dout1_6 vdout1_6ck77 = 1.8 time = 780
* CHECK dout1_7 vdout1_7ck77 = 0 time = 780
* CHECK dout1_8 vdout1_8ck77 = 1.8 time = 780
* CHECK dout1_9 vdout1_9ck77 = 0 time = 780
* CHECK dout1_10 vdout1_10ck77 = 1.8 time = 780
* CHECK dout1_11 vdout1_11ck77 = 1.8 time = 780
* CHECK dout1_12 vdout1_12ck77 = 1.8 time = 780
* CHECK dout1_13 vdout1_13ck77 = 1.8 time = 780
* CHECK dout1_14 vdout1_14ck77 = 0 time = 780
* CHECK dout1_15 vdout1_15ck77 = 1.8 time = 780
* CHECK dout1_16 vdout1_16ck77 = 1.8 time = 780
* CHECK dout1_17 vdout1_17ck77 = 1.8 time = 780
* CHECK dout1_18 vdout1_18ck77 = 0 time = 780
* CHECK dout1_19 vdout1_19ck77 = 0 time = 780
* CHECK dout1_20 vdout1_20ck77 = 1.8 time = 780
* CHECK dout1_21 vdout1_21ck77 = 0 time = 780
* CHECK dout1_22 vdout1_22ck77 = 0 time = 780
* CHECK dout1_23 vdout1_23ck77 = 0 time = 780
* CHECK dout1_24 vdout1_24ck77 = 0 time = 780
* CHECK dout1_25 vdout1_25ck77 = 0 time = 780
* CHECK dout1_26 vdout1_26ck77 = 1.8 time = 780
* CHECK dout1_27 vdout1_27ck77 = 1.8 time = 780
* CHECK dout1_28 vdout1_28ck77 = 0 time = 780
* CHECK dout1_29 vdout1_29ck77 = 1.8 time = 780
* CHECK dout1_30 vdout1_30ck77 = 0 time = 780
* CHECK dout1_31 vdout1_31ck77 = 0 time = 780
* CHECK dout0_0 vdout0_0ck79 = 0 time = 800
* CHECK dout0_1 vdout0_1ck79 = 1.8 time = 800
* CHECK dout0_2 vdout0_2ck79 = 0 time = 800
* CHECK dout0_3 vdout0_3ck79 = 1.8 time = 800
* CHECK dout0_4 vdout0_4ck79 = 1.8 time = 800
* CHECK dout0_5 vdout0_5ck79 = 0 time = 800
* CHECK dout0_6 vdout0_6ck79 = 1.8 time = 800
* CHECK dout0_7 vdout0_7ck79 = 0 time = 800
* CHECK dout0_8 vdout0_8ck79 = 1.8 time = 800
* CHECK dout0_9 vdout0_9ck79 = 0 time = 800
* CHECK dout0_10 vdout0_10ck79 = 0 time = 800
* CHECK dout0_11 vdout0_11ck79 = 1.8 time = 800
* CHECK dout0_12 vdout0_12ck79 = 0 time = 800
* CHECK dout0_13 vdout0_13ck79 = 0 time = 800
* CHECK dout0_14 vdout0_14ck79 = 1.8 time = 800
* CHECK dout0_15 vdout0_15ck79 = 1.8 time = 800
* CHECK dout0_16 vdout0_16ck79 = 1.8 time = 800
* CHECK dout0_17 vdout0_17ck79 = 1.8 time = 800
* CHECK dout0_18 vdout0_18ck79 = 1.8 time = 800
* CHECK dout0_19 vdout0_19ck79 = 1.8 time = 800
* CHECK dout0_20 vdout0_20ck79 = 0 time = 800
* CHECK dout0_21 vdout0_21ck79 = 0 time = 800
* CHECK dout0_22 vdout0_22ck79 = 1.8 time = 800
* CHECK dout0_23 vdout0_23ck79 = 1.8 time = 800
* CHECK dout0_24 vdout0_24ck79 = 0 time = 800
* CHECK dout0_25 vdout0_25ck79 = 0 time = 800
* CHECK dout0_26 vdout0_26ck79 = 0 time = 800
* CHECK dout0_27 vdout0_27ck79 = 0 time = 800
* CHECK dout0_28 vdout0_28ck79 = 0 time = 800
* CHECK dout0_29 vdout0_29ck79 = 0 time = 800
* CHECK dout0_30 vdout0_30ck79 = 1.8 time = 800
* CHECK dout0_31 vdout0_31ck79 = 0 time = 800
* CHECK dout1_0 vdout1_0ck79 = 1.8 time = 800
* CHECK dout1_1 vdout1_1ck79 = 0 time = 800
* CHECK dout1_2 vdout1_2ck79 = 0 time = 800
* CHECK dout1_3 vdout1_3ck79 = 0 time = 800
* CHECK dout1_4 vdout1_4ck79 = 0 time = 800
* CHECK dout1_5 vdout1_5ck79 = 0 time = 800
* CHECK dout1_6 vdout1_6ck79 = 0 time = 800
* CHECK dout1_7 vdout1_7ck79 = 0 time = 800
* CHECK dout1_8 vdout1_8ck79 = 0 time = 800
* CHECK dout1_9 vdout1_9ck79 = 1.8 time = 800
* CHECK dout1_10 vdout1_10ck79 = 0 time = 800
* CHECK dout1_11 vdout1_11ck79 = 0 time = 800
* CHECK dout1_12 vdout1_12ck79 = 1.8 time = 800
* CHECK dout1_13 vdout1_13ck79 = 1.8 time = 800
* CHECK dout1_14 vdout1_14ck79 = 0 time = 800
* CHECK dout1_15 vdout1_15ck79 = 1.8 time = 800
* CHECK dout1_16 vdout1_16ck79 = 0 time = 800
* CHECK dout1_17 vdout1_17ck79 = 0 time = 800
* CHECK dout1_18 vdout1_18ck79 = 0 time = 800
* CHECK dout1_19 vdout1_19ck79 = 1.8 time = 800
* CHECK dout1_20 vdout1_20ck79 = 0 time = 800
* CHECK dout1_21 vdout1_21ck79 = 0 time = 800
* CHECK dout1_22 vdout1_22ck79 = 0 time = 800
* CHECK dout1_23 vdout1_23ck79 = 0 time = 800
* CHECK dout1_24 vdout1_24ck79 = 0 time = 800
* CHECK dout1_25 vdout1_25ck79 = 1.8 time = 800
* CHECK dout1_26 vdout1_26ck79 = 1.8 time = 800
* CHECK dout1_27 vdout1_27ck79 = 0 time = 800
* CHECK dout1_28 vdout1_28ck79 = 0 time = 800
* CHECK dout1_29 vdout1_29ck79 = 0 time = 800
* CHECK dout1_30 vdout1_30ck79 = 0 time = 800
* CHECK dout1_31 vdout1_31ck79 = 1.8 time = 800
* CHECK dout1_0 vdout1_0ck80 = 0 time = 810
* CHECK dout1_1 vdout1_1ck80 = 1.8 time = 810
* CHECK dout1_2 vdout1_2ck80 = 0 time = 810
* CHECK dout1_3 vdout1_3ck80 = 1.8 time = 810
* CHECK dout1_4 vdout1_4ck80 = 1.8 time = 810
* CHECK dout1_5 vdout1_5ck80 = 0 time = 810
* CHECK dout1_6 vdout1_6ck80 = 1.8 time = 810
* CHECK dout1_7 vdout1_7ck80 = 0 time = 810
* CHECK dout1_8 vdout1_8ck80 = 1.8 time = 810
* CHECK dout1_9 vdout1_9ck80 = 0 time = 810
* CHECK dout1_10 vdout1_10ck80 = 0 time = 810
* CHECK dout1_11 vdout1_11ck80 = 1.8 time = 810
* CHECK dout1_12 vdout1_12ck80 = 0 time = 810
* CHECK dout1_13 vdout1_13ck80 = 0 time = 810
* CHECK dout1_14 vdout1_14ck80 = 1.8 time = 810
* CHECK dout1_15 vdout1_15ck80 = 1.8 time = 810
* CHECK dout1_16 vdout1_16ck80 = 1.8 time = 810
* CHECK dout1_17 vdout1_17ck80 = 1.8 time = 810
* CHECK dout1_18 vdout1_18ck80 = 1.8 time = 810
* CHECK dout1_19 vdout1_19ck80 = 1.8 time = 810
* CHECK dout1_20 vdout1_20ck80 = 0 time = 810
* CHECK dout1_21 vdout1_21ck80 = 0 time = 810
* CHECK dout1_22 vdout1_22ck80 = 1.8 time = 810
* CHECK dout1_23 vdout1_23ck80 = 1.8 time = 810
* CHECK dout1_24 vdout1_24ck80 = 0 time = 810
* CHECK dout1_25 vdout1_25ck80 = 0 time = 810
* CHECK dout1_26 vdout1_26ck80 = 0 time = 810
* CHECK dout1_27 vdout1_27ck80 = 0 time = 810
* CHECK dout1_28 vdout1_28ck80 = 0 time = 810
* CHECK dout1_29 vdout1_29ck80 = 0 time = 810
* CHECK dout1_30 vdout1_30ck80 = 1.8 time = 810
* CHECK dout1_31 vdout1_31ck80 = 0 time = 810
* CHECK dout0_0 vdout0_0ck81 = 0 time = 820
* CHECK dout0_1 vdout0_1ck81 = 1.8 time = 820
* CHECK dout0_2 vdout0_2ck81 = 0 time = 820
* CHECK dout0_3 vdout0_3ck81 = 1.8 time = 820
* CHECK dout0_4 vdout0_4ck81 = 1.8 time = 820
* CHECK dout0_5 vdout0_5ck81 = 0 time = 820
* CHECK dout0_6 vdout0_6ck81 = 1.8 time = 820
* CHECK dout0_7 vdout0_7ck81 = 0 time = 820
* CHECK dout0_8 vdout0_8ck81 = 1.8 time = 820
* CHECK dout0_9 vdout0_9ck81 = 0 time = 820
* CHECK dout0_10 vdout0_10ck81 = 0 time = 820
* CHECK dout0_11 vdout0_11ck81 = 1.8 time = 820
* CHECK dout0_12 vdout0_12ck81 = 0 time = 820
* CHECK dout0_13 vdout0_13ck81 = 0 time = 820
* CHECK dout0_14 vdout0_14ck81 = 1.8 time = 820
* CHECK dout0_15 vdout0_15ck81 = 1.8 time = 820
* CHECK dout0_16 vdout0_16ck81 = 1.8 time = 820
* CHECK dout0_17 vdout0_17ck81 = 1.8 time = 820
* CHECK dout0_18 vdout0_18ck81 = 1.8 time = 820
* CHECK dout0_19 vdout0_19ck81 = 1.8 time = 820
* CHECK dout0_20 vdout0_20ck81 = 0 time = 820
* CHECK dout0_21 vdout0_21ck81 = 0 time = 820
* CHECK dout0_22 vdout0_22ck81 = 1.8 time = 820
* CHECK dout0_23 vdout0_23ck81 = 1.8 time = 820
* CHECK dout0_24 vdout0_24ck81 = 0 time = 820
* CHECK dout0_25 vdout0_25ck81 = 0 time = 820
* CHECK dout0_26 vdout0_26ck81 = 0 time = 820
* CHECK dout0_27 vdout0_27ck81 = 0 time = 820
* CHECK dout0_28 vdout0_28ck81 = 0 time = 820
* CHECK dout0_29 vdout0_29ck81 = 0 time = 820
* CHECK dout0_30 vdout0_30ck81 = 1.8 time = 820
* CHECK dout0_31 vdout0_31ck81 = 0 time = 820
* CHECK dout1_0 vdout1_0ck81 = 1.8 time = 820
* CHECK dout1_1 vdout1_1ck81 = 0 time = 820
* CHECK dout1_2 vdout1_2ck81 = 0 time = 820
* CHECK dout1_3 vdout1_3ck81 = 0 time = 820
* CHECK dout1_4 vdout1_4ck81 = 1.8 time = 820
* CHECK dout1_5 vdout1_5ck81 = 0 time = 820
* CHECK dout1_6 vdout1_6ck81 = 0 time = 820
* CHECK dout1_7 vdout1_7ck81 = 0 time = 820
* CHECK dout1_8 vdout1_8ck81 = 0 time = 820
* CHECK dout1_9 vdout1_9ck81 = 0 time = 820
* CHECK dout1_10 vdout1_10ck81 = 0 time = 820
* CHECK dout1_11 vdout1_11ck81 = 1.8 time = 820
* CHECK dout1_12 vdout1_12ck81 = 1.8 time = 820
* CHECK dout1_13 vdout1_13ck81 = 0 time = 820
* CHECK dout1_14 vdout1_14ck81 = 0 time = 820
* CHECK dout1_15 vdout1_15ck81 = 1.8 time = 820
* CHECK dout1_16 vdout1_16ck81 = 0 time = 820
* CHECK dout1_17 vdout1_17ck81 = 0 time = 820
* CHECK dout1_18 vdout1_18ck81 = 0 time = 820
* CHECK dout1_19 vdout1_19ck81 = 0 time = 820
* CHECK dout1_20 vdout1_20ck81 = 0 time = 820
* CHECK dout1_21 vdout1_21ck81 = 1.8 time = 820
* CHECK dout1_22 vdout1_22ck81 = 0 time = 820
* CHECK dout1_23 vdout1_23ck81 = 0 time = 820
* CHECK dout1_24 vdout1_24ck81 = 1.8 time = 820
* CHECK dout1_25 vdout1_25ck81 = 0 time = 820
* CHECK dout1_26 vdout1_26ck81 = 1.8 time = 820
* CHECK dout1_27 vdout1_27ck81 = 0 time = 820
* CHECK dout1_28 vdout1_28ck81 = 1.8 time = 820
* CHECK dout1_29 vdout1_29ck81 = 1.8 time = 820
* CHECK dout1_30 vdout1_30ck81 = 0 time = 820
* CHECK dout1_31 vdout1_31ck81 = 1.8 time = 820
* CHECK dout1_0 vdout1_0ck82 = 1.8 time = 830
* CHECK dout1_1 vdout1_1ck82 = 0 time = 830
* CHECK dout1_2 vdout1_2ck82 = 1.8 time = 830
* CHECK dout1_3 vdout1_3ck82 = 1.8 time = 830
* CHECK dout1_4 vdout1_4ck82 = 0 time = 830
* CHECK dout1_5 vdout1_5ck82 = 0 time = 830
* CHECK dout1_6 vdout1_6ck82 = 0 time = 830
* CHECK dout1_7 vdout1_7ck82 = 0 time = 830
* CHECK dout1_8 vdout1_8ck82 = 0 time = 830
* CHECK dout1_9 vdout1_9ck82 = 0 time = 830
* CHECK dout1_10 vdout1_10ck82 = 0 time = 830
* CHECK dout1_11 vdout1_11ck82 = 1.8 time = 830
* CHECK dout1_12 vdout1_12ck82 = 0 time = 830
* CHECK dout1_13 vdout1_13ck82 = 0 time = 830
* CHECK dout1_14 vdout1_14ck82 = 0 time = 830
* CHECK dout1_15 vdout1_15ck82 = 0 time = 830
* CHECK dout1_16 vdout1_16ck82 = 0 time = 830
* CHECK dout1_17 vdout1_17ck82 = 1.8 time = 830
* CHECK dout1_18 vdout1_18ck82 = 0 time = 830
* CHECK dout1_19 vdout1_19ck82 = 1.8 time = 830
* CHECK dout1_20 vdout1_20ck82 = 0 time = 830
* CHECK dout1_21 vdout1_21ck82 = 1.8 time = 830
* CHECK dout1_22 vdout1_22ck82 = 0 time = 830
* CHECK dout1_23 vdout1_23ck82 = 1.8 time = 830
* CHECK dout1_24 vdout1_24ck82 = 0 time = 830
* CHECK dout1_25 vdout1_25ck82 = 0 time = 830
* CHECK dout1_26 vdout1_26ck82 = 0 time = 830
* CHECK dout1_27 vdout1_27ck82 = 0 time = 830
* CHECK dout1_28 vdout1_28ck82 = 0 time = 830
* CHECK dout1_29 vdout1_29ck82 = 1.8 time = 830
* CHECK dout1_30 vdout1_30ck82 = 0 time = 830
* CHECK dout1_31 vdout1_31ck82 = 0 time = 830
* CHECK dout0_0 vdout0_0ck83 = 1.8 time = 840
* CHECK dout0_1 vdout0_1ck83 = 0 time = 840
* CHECK dout0_2 vdout0_2ck83 = 1.8 time = 840
* CHECK dout0_3 vdout0_3ck83 = 1.8 time = 840
* CHECK dout0_4 vdout0_4ck83 = 0 time = 840
* CHECK dout0_5 vdout0_5ck83 = 0 time = 840
* CHECK dout0_6 vdout0_6ck83 = 0 time = 840
* CHECK dout0_7 vdout0_7ck83 = 0 time = 840
* CHECK dout0_8 vdout0_8ck83 = 0 time = 840
* CHECK dout0_9 vdout0_9ck83 = 0 time = 840
* CHECK dout0_10 vdout0_10ck83 = 0 time = 840
* CHECK dout0_11 vdout0_11ck83 = 1.8 time = 840
* CHECK dout0_12 vdout0_12ck83 = 0 time = 840
* CHECK dout0_13 vdout0_13ck83 = 0 time = 840
* CHECK dout0_14 vdout0_14ck83 = 0 time = 840
* CHECK dout0_15 vdout0_15ck83 = 0 time = 840
* CHECK dout0_16 vdout0_16ck83 = 0 time = 840
* CHECK dout0_17 vdout0_17ck83 = 1.8 time = 840
* CHECK dout0_18 vdout0_18ck83 = 0 time = 840
* CHECK dout0_19 vdout0_19ck83 = 1.8 time = 840
* CHECK dout0_20 vdout0_20ck83 = 0 time = 840
* CHECK dout0_21 vdout0_21ck83 = 1.8 time = 840
* CHECK dout0_22 vdout0_22ck83 = 0 time = 840
* CHECK dout0_23 vdout0_23ck83 = 1.8 time = 840
* CHECK dout0_24 vdout0_24ck83 = 0 time = 840
* CHECK dout0_25 vdout0_25ck83 = 0 time = 840
* CHECK dout0_26 vdout0_26ck83 = 0 time = 840
* CHECK dout0_27 vdout0_27ck83 = 0 time = 840
* CHECK dout0_28 vdout0_28ck83 = 0 time = 840
* CHECK dout0_29 vdout0_29ck83 = 1.8 time = 840
* CHECK dout0_30 vdout0_30ck83 = 0 time = 840
* CHECK dout0_31 vdout0_31ck83 = 0 time = 840
* CHECK dout1_0 vdout1_0ck83 = 1.8 time = 840
* CHECK dout1_1 vdout1_1ck83 = 0 time = 840
* CHECK dout1_2 vdout1_2ck83 = 0 time = 840
* CHECK dout1_3 vdout1_3ck83 = 0 time = 840
* CHECK dout1_4 vdout1_4ck83 = 0 time = 840
* CHECK dout1_5 vdout1_5ck83 = 0 time = 840
* CHECK dout1_6 vdout1_6ck83 = 0 time = 840
* CHECK dout1_7 vdout1_7ck83 = 0 time = 840
* CHECK dout1_8 vdout1_8ck83 = 0 time = 840
* CHECK dout1_9 vdout1_9ck83 = 1.8 time = 840
* CHECK dout1_10 vdout1_10ck83 = 0 time = 840
* CHECK dout1_11 vdout1_11ck83 = 0 time = 840
* CHECK dout1_12 vdout1_12ck83 = 1.8 time = 840
* CHECK dout1_13 vdout1_13ck83 = 1.8 time = 840
* CHECK dout1_14 vdout1_14ck83 = 0 time = 840
* CHECK dout1_15 vdout1_15ck83 = 1.8 time = 840
* CHECK dout1_16 vdout1_16ck83 = 0 time = 840
* CHECK dout1_17 vdout1_17ck83 = 0 time = 840
* CHECK dout1_18 vdout1_18ck83 = 0 time = 840
* CHECK dout1_19 vdout1_19ck83 = 1.8 time = 840
* CHECK dout1_20 vdout1_20ck83 = 0 time = 840
* CHECK dout1_21 vdout1_21ck83 = 0 time = 840
* CHECK dout1_22 vdout1_22ck83 = 0 time = 840
* CHECK dout1_23 vdout1_23ck83 = 0 time = 840
* CHECK dout1_24 vdout1_24ck83 = 0 time = 840
* CHECK dout1_25 vdout1_25ck83 = 1.8 time = 840
* CHECK dout1_26 vdout1_26ck83 = 1.8 time = 840
* CHECK dout1_27 vdout1_27ck83 = 0 time = 840
* CHECK dout1_28 vdout1_28ck83 = 0 time = 840
* CHECK dout1_29 vdout1_29ck83 = 0 time = 840
* CHECK dout1_30 vdout1_30ck83 = 0 time = 840
* CHECK dout1_31 vdout1_31ck83 = 1.8 time = 840
* CHECK dout1_0 vdout1_0ck84 = 1.8 time = 850
* CHECK dout1_1 vdout1_1ck84 = 0 time = 850
* CHECK dout1_2 vdout1_2ck84 = 0 time = 850
* CHECK dout1_3 vdout1_3ck84 = 0 time = 850
* CHECK dout1_4 vdout1_4ck84 = 1.8 time = 850
* CHECK dout1_5 vdout1_5ck84 = 0 time = 850
* CHECK dout1_6 vdout1_6ck84 = 0 time = 850
* CHECK dout1_7 vdout1_7ck84 = 0 time = 850
* CHECK dout1_8 vdout1_8ck84 = 0 time = 850
* CHECK dout1_9 vdout1_9ck84 = 0 time = 850
* CHECK dout1_10 vdout1_10ck84 = 0 time = 850
* CHECK dout1_11 vdout1_11ck84 = 1.8 time = 850
* CHECK dout1_12 vdout1_12ck84 = 1.8 time = 850
* CHECK dout1_13 vdout1_13ck84 = 0 time = 850
* CHECK dout1_14 vdout1_14ck84 = 0 time = 850
* CHECK dout1_15 vdout1_15ck84 = 1.8 time = 850
* CHECK dout1_16 vdout1_16ck84 = 0 time = 850
* CHECK dout1_17 vdout1_17ck84 = 0 time = 850
* CHECK dout1_18 vdout1_18ck84 = 0 time = 850
* CHECK dout1_19 vdout1_19ck84 = 0 time = 850
* CHECK dout1_20 vdout1_20ck84 = 0 time = 850
* CHECK dout1_21 vdout1_21ck84 = 1.8 time = 850
* CHECK dout1_22 vdout1_22ck84 = 0 time = 850
* CHECK dout1_23 vdout1_23ck84 = 0 time = 850
* CHECK dout1_24 vdout1_24ck84 = 1.8 time = 850
* CHECK dout1_25 vdout1_25ck84 = 0 time = 850
* CHECK dout1_26 vdout1_26ck84 = 1.8 time = 850
* CHECK dout1_27 vdout1_27ck84 = 0 time = 850
* CHECK dout1_28 vdout1_28ck84 = 1.8 time = 850
* CHECK dout1_29 vdout1_29ck84 = 1.8 time = 850
* CHECK dout1_30 vdout1_30ck84 = 0 time = 850
* CHECK dout1_31 vdout1_31ck84 = 1.8 time = 850
* CHECK dout0_0 vdout0_0ck85 = 0 time = 860
* CHECK dout0_1 vdout0_1ck85 = 1.8 time = 860
* CHECK dout0_2 vdout0_2ck85 = 0 time = 860
* CHECK dout0_3 vdout0_3ck85 = 1.8 time = 860
* CHECK dout0_4 vdout0_4ck85 = 1.8 time = 860
* CHECK dout0_5 vdout0_5ck85 = 0 time = 860
* CHECK dout0_6 vdout0_6ck85 = 1.8 time = 860
* CHECK dout0_7 vdout0_7ck85 = 0 time = 860
* CHECK dout0_8 vdout0_8ck85 = 1.8 time = 860
* CHECK dout0_9 vdout0_9ck85 = 0 time = 860
* CHECK dout0_10 vdout0_10ck85 = 1.8 time = 860
* CHECK dout0_11 vdout0_11ck85 = 1.8 time = 860
* CHECK dout0_12 vdout0_12ck85 = 0 time = 860
* CHECK dout0_13 vdout0_13ck85 = 1.8 time = 860
* CHECK dout0_14 vdout0_14ck85 = 0 time = 860
* CHECK dout0_15 vdout0_15ck85 = 1.8 time = 860
* CHECK dout0_16 vdout0_16ck85 = 1.8 time = 860
* CHECK dout0_17 vdout0_17ck85 = 1.8 time = 860
* CHECK dout0_18 vdout0_18ck85 = 1.8 time = 860
* CHECK dout0_19 vdout0_19ck85 = 1.8 time = 860
* CHECK dout0_20 vdout0_20ck85 = 0 time = 860
* CHECK dout0_21 vdout0_21ck85 = 0 time = 860
* CHECK dout0_22 vdout0_22ck85 = 1.8 time = 860
* CHECK dout0_23 vdout0_23ck85 = 1.8 time = 860
* CHECK dout0_24 vdout0_24ck85 = 0 time = 860
* CHECK dout0_25 vdout0_25ck85 = 0 time = 860
* CHECK dout0_26 vdout0_26ck85 = 0 time = 860
* CHECK dout0_27 vdout0_27ck85 = 0 time = 860
* CHECK dout0_28 vdout0_28ck85 = 0 time = 860
* CHECK dout0_29 vdout0_29ck85 = 0 time = 860
* CHECK dout0_30 vdout0_30ck85 = 1.8 time = 860
* CHECK dout0_31 vdout0_31ck85 = 0 time = 860
* CHECK dout1_0 vdout1_0ck85 = 0 time = 860
* CHECK dout1_1 vdout1_1ck85 = 1.8 time = 860
* CHECK dout1_2 vdout1_2ck85 = 0 time = 860
* CHECK dout1_3 vdout1_3ck85 = 1.8 time = 860
* CHECK dout1_4 vdout1_4ck85 = 1.8 time = 860
* CHECK dout1_5 vdout1_5ck85 = 0 time = 860
* CHECK dout1_6 vdout1_6ck85 = 1.8 time = 860
* CHECK dout1_7 vdout1_7ck85 = 0 time = 860
* CHECK dout1_8 vdout1_8ck85 = 1.8 time = 860
* CHECK dout1_9 vdout1_9ck85 = 0 time = 860
* CHECK dout1_10 vdout1_10ck85 = 1.8 time = 860
* CHECK dout1_11 vdout1_11ck85 = 1.8 time = 860
* CHECK dout1_12 vdout1_12ck85 = 0 time = 860
* CHECK dout1_13 vdout1_13ck85 = 1.8 time = 860
* CHECK dout1_14 vdout1_14ck85 = 0 time = 860
* CHECK dout1_15 vdout1_15ck85 = 1.8 time = 860
* CHECK dout1_16 vdout1_16ck85 = 1.8 time = 860
* CHECK dout1_17 vdout1_17ck85 = 1.8 time = 860
* CHECK dout1_18 vdout1_18ck85 = 1.8 time = 860
* CHECK dout1_19 vdout1_19ck85 = 1.8 time = 860
* CHECK dout1_20 vdout1_20ck85 = 0 time = 860
* CHECK dout1_21 vdout1_21ck85 = 0 time = 860
* CHECK dout1_22 vdout1_22ck85 = 1.8 time = 860
* CHECK dout1_23 vdout1_23ck85 = 1.8 time = 860
* CHECK dout1_24 vdout1_24ck85 = 0 time = 860
* CHECK dout1_25 vdout1_25ck85 = 0 time = 860
* CHECK dout1_26 vdout1_26ck85 = 0 time = 860
* CHECK dout1_27 vdout1_27ck85 = 0 time = 860
* CHECK dout1_28 vdout1_28ck85 = 0 time = 860
* CHECK dout1_29 vdout1_29ck85 = 0 time = 860
* CHECK dout1_30 vdout1_30ck85 = 1.8 time = 860
* CHECK dout1_31 vdout1_31ck85 = 0 time = 860
* CHECK dout1_0 vdout1_0ck86 = 1.8 time = 870
* CHECK dout1_1 vdout1_1ck86 = 0 time = 870
* CHECK dout1_2 vdout1_2ck86 = 1.8 time = 870
* CHECK dout1_3 vdout1_3ck86 = 1.8 time = 870
* CHECK dout1_4 vdout1_4ck86 = 0 time = 870
* CHECK dout1_5 vdout1_5ck86 = 0 time = 870
* CHECK dout1_6 vdout1_6ck86 = 0 time = 870
* CHECK dout1_7 vdout1_7ck86 = 0 time = 870
* CHECK dout1_8 vdout1_8ck86 = 0 time = 870
* CHECK dout1_9 vdout1_9ck86 = 0 time = 870
* CHECK dout1_10 vdout1_10ck86 = 0 time = 870
* CHECK dout1_11 vdout1_11ck86 = 1.8 time = 870
* CHECK dout1_12 vdout1_12ck86 = 0 time = 870
* CHECK dout1_13 vdout1_13ck86 = 0 time = 870
* CHECK dout1_14 vdout1_14ck86 = 0 time = 870
* CHECK dout1_15 vdout1_15ck86 = 0 time = 870
* CHECK dout1_16 vdout1_16ck86 = 0 time = 870
* CHECK dout1_17 vdout1_17ck86 = 1.8 time = 870
* CHECK dout1_18 vdout1_18ck86 = 0 time = 870
* CHECK dout1_19 vdout1_19ck86 = 1.8 time = 870
* CHECK dout1_20 vdout1_20ck86 = 0 time = 870
* CHECK dout1_21 vdout1_21ck86 = 1.8 time = 870
* CHECK dout1_22 vdout1_22ck86 = 0 time = 870
* CHECK dout1_23 vdout1_23ck86 = 1.8 time = 870
* CHECK dout1_24 vdout1_24ck86 = 0 time = 870
* CHECK dout1_25 vdout1_25ck86 = 0 time = 870
* CHECK dout1_26 vdout1_26ck86 = 0 time = 870
* CHECK dout1_27 vdout1_27ck86 = 0 time = 870
* CHECK dout1_28 vdout1_28ck86 = 0 time = 870
* CHECK dout1_29 vdout1_29ck86 = 1.8 time = 870
* CHECK dout1_30 vdout1_30ck86 = 0 time = 870
* CHECK dout1_31 vdout1_31ck86 = 0 time = 870
* CHECK dout1_0 vdout1_0ck87 = 1.8 time = 880
* CHECK dout1_1 vdout1_1ck87 = 0 time = 880
* CHECK dout1_2 vdout1_2ck87 = 1.8 time = 880
* CHECK dout1_3 vdout1_3ck87 = 1.8 time = 880
* CHECK dout1_4 vdout1_4ck87 = 0 time = 880
* CHECK dout1_5 vdout1_5ck87 = 0 time = 880
* CHECK dout1_6 vdout1_6ck87 = 0 time = 880
* CHECK dout1_7 vdout1_7ck87 = 0 time = 880
* CHECK dout1_8 vdout1_8ck87 = 0 time = 880
* CHECK dout1_9 vdout1_9ck87 = 0 time = 880
* CHECK dout1_10 vdout1_10ck87 = 0 time = 880
* CHECK dout1_11 vdout1_11ck87 = 1.8 time = 880
* CHECK dout1_12 vdout1_12ck87 = 0 time = 880
* CHECK dout1_13 vdout1_13ck87 = 0 time = 880
* CHECK dout1_14 vdout1_14ck87 = 0 time = 880
* CHECK dout1_15 vdout1_15ck87 = 0 time = 880
* CHECK dout1_16 vdout1_16ck87 = 0 time = 880
* CHECK dout1_17 vdout1_17ck87 = 1.8 time = 880
* CHECK dout1_18 vdout1_18ck87 = 0 time = 880
* CHECK dout1_19 vdout1_19ck87 = 1.8 time = 880
* CHECK dout1_20 vdout1_20ck87 = 0 time = 880
* CHECK dout1_21 vdout1_21ck87 = 1.8 time = 880
* CHECK dout1_22 vdout1_22ck87 = 0 time = 880
* CHECK dout1_23 vdout1_23ck87 = 1.8 time = 880
* CHECK dout1_24 vdout1_24ck87 = 0 time = 880
* CHECK dout1_25 vdout1_25ck87 = 0 time = 880
* CHECK dout1_26 vdout1_26ck87 = 0 time = 880
* CHECK dout1_27 vdout1_27ck87 = 0 time = 880
* CHECK dout1_28 vdout1_28ck87 = 0 time = 880
* CHECK dout1_29 vdout1_29ck87 = 1.8 time = 880
* CHECK dout1_30 vdout1_30ck87 = 0 time = 880
* CHECK dout1_31 vdout1_31ck87 = 0 time = 880
* CHECK dout0_0 vdout0_0ck88 = 1.8 time = 890
* CHECK dout0_1 vdout0_1ck88 = 0 time = 890
* CHECK dout0_2 vdout0_2ck88 = 1.8 time = 890
* CHECK dout0_3 vdout0_3ck88 = 1.8 time = 890
* CHECK dout0_4 vdout0_4ck88 = 0 time = 890
* CHECK dout0_5 vdout0_5ck88 = 0 time = 890
* CHECK dout0_6 vdout0_6ck88 = 0 time = 890
* CHECK dout0_7 vdout0_7ck88 = 0 time = 890
* CHECK dout0_8 vdout0_8ck88 = 0 time = 890
* CHECK dout0_9 vdout0_9ck88 = 0 time = 890
* CHECK dout0_10 vdout0_10ck88 = 0 time = 890
* CHECK dout0_11 vdout0_11ck88 = 1.8 time = 890
* CHECK dout0_12 vdout0_12ck88 = 0 time = 890
* CHECK dout0_13 vdout0_13ck88 = 0 time = 890
* CHECK dout0_14 vdout0_14ck88 = 0 time = 890
* CHECK dout0_15 vdout0_15ck88 = 0 time = 890
* CHECK dout0_16 vdout0_16ck88 = 0 time = 890
* CHECK dout0_17 vdout0_17ck88 = 1.8 time = 890
* CHECK dout0_18 vdout0_18ck88 = 0 time = 890
* CHECK dout0_19 vdout0_19ck88 = 1.8 time = 890
* CHECK dout0_20 vdout0_20ck88 = 0 time = 890
* CHECK dout0_21 vdout0_21ck88 = 1.8 time = 890
* CHECK dout0_22 vdout0_22ck88 = 0 time = 890
* CHECK dout0_23 vdout0_23ck88 = 1.8 time = 890
* CHECK dout0_24 vdout0_24ck88 = 0 time = 890
* CHECK dout0_25 vdout0_25ck88 = 0 time = 890
* CHECK dout0_26 vdout0_26ck88 = 0 time = 890
* CHECK dout0_27 vdout0_27ck88 = 0 time = 890
* CHECK dout0_28 vdout0_28ck88 = 0 time = 890
* CHECK dout0_29 vdout0_29ck88 = 1.8 time = 890
* CHECK dout0_30 vdout0_30ck88 = 0 time = 890
* CHECK dout0_31 vdout0_31ck88 = 0 time = 890
* CHECK dout0_0 vdout0_0ck89 = 0 time = 900
* CHECK dout0_1 vdout0_1ck89 = 1.8 time = 900
* CHECK dout0_2 vdout0_2ck89 = 0 time = 900
* CHECK dout0_3 vdout0_3ck89 = 0 time = 900
* CHECK dout0_4 vdout0_4ck89 = 1.8 time = 900
* CHECK dout0_5 vdout0_5ck89 = 1.8 time = 900
* CHECK dout0_6 vdout0_6ck89 = 1.8 time = 900
* CHECK dout0_7 vdout0_7ck89 = 1.8 time = 900
* CHECK dout0_8 vdout0_8ck89 = 0 time = 900
* CHECK dout0_9 vdout0_9ck89 = 1.8 time = 900
* CHECK dout0_10 vdout0_10ck89 = 1.8 time = 900
* CHECK dout0_11 vdout0_11ck89 = 0 time = 900
* CHECK dout0_12 vdout0_12ck89 = 1.8 time = 900
* CHECK dout0_13 vdout0_13ck89 = 0 time = 900
* CHECK dout0_14 vdout0_14ck89 = 1.8 time = 900
* CHECK dout0_15 vdout0_15ck89 = 0 time = 900
* CHECK dout0_16 vdout0_16ck89 = 1.8 time = 900
* CHECK dout0_17 vdout0_17ck89 = 1.8 time = 900
* CHECK dout0_18 vdout0_18ck89 = 1.8 time = 900
* CHECK dout0_19 vdout0_19ck89 = 0 time = 900
* CHECK dout0_20 vdout0_20ck89 = 1.8 time = 900
* CHECK dout0_21 vdout0_21ck89 = 1.8 time = 900
* CHECK dout0_22 vdout0_22ck89 = 0 time = 900
* CHECK dout0_23 vdout0_23ck89 = 0 time = 900
* CHECK dout0_24 vdout0_24ck89 = 1.8 time = 900
* CHECK dout0_25 vdout0_25ck89 = 0 time = 900
* CHECK dout0_26 vdout0_26ck89 = 1.8 time = 900
* CHECK dout0_27 vdout0_27ck89 = 1.8 time = 900
* CHECK dout0_28 vdout0_28ck89 = 0 time = 900
* CHECK dout0_29 vdout0_29ck89 = 0 time = 900
* CHECK dout0_30 vdout0_30ck89 = 1.8 time = 900
* CHECK dout0_31 vdout0_31ck89 = 0 time = 900
* CHECK dout0_0 vdout0_0ck90 = 1.8 time = 910
* CHECK dout0_1 vdout0_1ck90 = 0 time = 910
* CHECK dout0_2 vdout0_2ck90 = 0 time = 910
* CHECK dout0_3 vdout0_3ck90 = 0 time = 910
* CHECK dout0_4 vdout0_4ck90 = 1.8 time = 910
* CHECK dout0_5 vdout0_5ck90 = 0 time = 910
* CHECK dout0_6 vdout0_6ck90 = 0 time = 910
* CHECK dout0_7 vdout0_7ck90 = 0 time = 910
* CHECK dout0_8 vdout0_8ck90 = 0 time = 910
* CHECK dout0_9 vdout0_9ck90 = 0 time = 910
* CHECK dout0_10 vdout0_10ck90 = 0 time = 910
* CHECK dout0_11 vdout0_11ck90 = 1.8 time = 910
* CHECK dout0_12 vdout0_12ck90 = 1.8 time = 910
* CHECK dout0_13 vdout0_13ck90 = 0 time = 910
* CHECK dout0_14 vdout0_14ck90 = 0 time = 910
* CHECK dout0_15 vdout0_15ck90 = 1.8 time = 910
* CHECK dout0_16 vdout0_16ck90 = 0 time = 910
* CHECK dout0_17 vdout0_17ck90 = 0 time = 910
* CHECK dout0_18 vdout0_18ck90 = 0 time = 910
* CHECK dout0_19 vdout0_19ck90 = 0 time = 910
* CHECK dout0_20 vdout0_20ck90 = 0 time = 910
* CHECK dout0_21 vdout0_21ck90 = 1.8 time = 910
* CHECK dout0_22 vdout0_22ck90 = 0 time = 910
* CHECK dout0_23 vdout0_23ck90 = 0 time = 910
* CHECK dout0_24 vdout0_24ck90 = 1.8 time = 910
* CHECK dout0_25 vdout0_25ck90 = 0 time = 910
* CHECK dout0_26 vdout0_26ck90 = 1.8 time = 910
* CHECK dout0_27 vdout0_27ck90 = 0 time = 910
* CHECK dout0_28 vdout0_28ck90 = 1.8 time = 910
* CHECK dout0_29 vdout0_29ck90 = 1.8 time = 910
* CHECK dout0_30 vdout0_30ck90 = 0 time = 910
* CHECK dout0_31 vdout0_31ck90 = 1.8 time = 910
* CHECK dout0_0 vdout0_0ck91 = 1.8 time = 920
* CHECK dout0_1 vdout0_1ck91 = 0 time = 920
* CHECK dout0_2 vdout0_2ck91 = 1.8 time = 920
* CHECK dout0_3 vdout0_3ck91 = 1.8 time = 920
* CHECK dout0_4 vdout0_4ck91 = 0 time = 920
* CHECK dout0_5 vdout0_5ck91 = 0 time = 920
* CHECK dout0_6 vdout0_6ck91 = 0 time = 920
* CHECK dout0_7 vdout0_7ck91 = 0 time = 920
* CHECK dout0_8 vdout0_8ck91 = 0 time = 920
* CHECK dout0_9 vdout0_9ck91 = 0 time = 920
* CHECK dout0_10 vdout0_10ck91 = 0 time = 920
* CHECK dout0_11 vdout0_11ck91 = 1.8 time = 920
* CHECK dout0_12 vdout0_12ck91 = 0 time = 920
* CHECK dout0_13 vdout0_13ck91 = 0 time = 920
* CHECK dout0_14 vdout0_14ck91 = 0 time = 920
* CHECK dout0_15 vdout0_15ck91 = 0 time = 920
* CHECK dout0_16 vdout0_16ck91 = 0 time = 920
* CHECK dout0_17 vdout0_17ck91 = 1.8 time = 920
* CHECK dout0_18 vdout0_18ck91 = 0 time = 920
* CHECK dout0_19 vdout0_19ck91 = 1.8 time = 920
* CHECK dout0_20 vdout0_20ck91 = 0 time = 920
* CHECK dout0_21 vdout0_21ck91 = 1.8 time = 920
* CHECK dout0_22 vdout0_22ck91 = 0 time = 920
* CHECK dout0_23 vdout0_23ck91 = 1.8 time = 920
* CHECK dout0_24 vdout0_24ck91 = 0 time = 920
* CHECK dout0_25 vdout0_25ck91 = 0 time = 920
* CHECK dout0_26 vdout0_26ck91 = 0 time = 920
* CHECK dout0_27 vdout0_27ck91 = 0 time = 920
* CHECK dout0_28 vdout0_28ck91 = 0 time = 920
* CHECK dout0_29 vdout0_29ck91 = 1.8 time = 920
* CHECK dout0_30 vdout0_30ck91 = 0 time = 920
* CHECK dout0_31 vdout0_31ck91 = 0 time = 920
* CHECK dout1_0 vdout1_0ck91 = 1.8 time = 920
* CHECK dout1_1 vdout1_1ck91 = 0 time = 920
* CHECK dout1_2 vdout1_2ck91 = 0 time = 920
* CHECK dout1_3 vdout1_3ck91 = 0 time = 920
* CHECK dout1_4 vdout1_4ck91 = 1.8 time = 920
* CHECK dout1_5 vdout1_5ck91 = 0 time = 920
* CHECK dout1_6 vdout1_6ck91 = 0 time = 920
* CHECK dout1_7 vdout1_7ck91 = 0 time = 920
* CHECK dout1_8 vdout1_8ck91 = 0 time = 920
* CHECK dout1_9 vdout1_9ck91 = 0 time = 920
* CHECK dout1_10 vdout1_10ck91 = 0 time = 920
* CHECK dout1_11 vdout1_11ck91 = 1.8 time = 920
* CHECK dout1_12 vdout1_12ck91 = 1.8 time = 920
* CHECK dout1_13 vdout1_13ck91 = 0 time = 920
* CHECK dout1_14 vdout1_14ck91 = 0 time = 920
* CHECK dout1_15 vdout1_15ck91 = 1.8 time = 920
* CHECK dout1_16 vdout1_16ck91 = 0 time = 920
* CHECK dout1_17 vdout1_17ck91 = 0 time = 920
* CHECK dout1_18 vdout1_18ck91 = 0 time = 920
* CHECK dout1_19 vdout1_19ck91 = 0 time = 920
* CHECK dout1_20 vdout1_20ck91 = 0 time = 920
* CHECK dout1_21 vdout1_21ck91 = 1.8 time = 920
* CHECK dout1_22 vdout1_22ck91 = 0 time = 920
* CHECK dout1_23 vdout1_23ck91 = 0 time = 920
* CHECK dout1_24 vdout1_24ck91 = 1.8 time = 920
* CHECK dout1_25 vdout1_25ck91 = 0 time = 920
* CHECK dout1_26 vdout1_26ck91 = 1.8 time = 920
* CHECK dout1_27 vdout1_27ck91 = 0 time = 920
* CHECK dout1_28 vdout1_28ck91 = 1.8 time = 920
* CHECK dout1_29 vdout1_29ck91 = 1.8 time = 920
* CHECK dout1_30 vdout1_30ck91 = 0 time = 920
* CHECK dout1_31 vdout1_31ck91 = 1.8 time = 920
* CHECK dout0_0 vdout0_0ck93 = 1.8 time = 940
* CHECK dout0_1 vdout0_1ck93 = 0 time = 940
* CHECK dout0_2 vdout0_2ck93 = 0 time = 940
* CHECK dout0_3 vdout0_3ck93 = 0 time = 940
* CHECK dout0_4 vdout0_4ck93 = 0 time = 940
* CHECK dout0_5 vdout0_5ck93 = 0 time = 940
* CHECK dout0_6 vdout0_6ck93 = 0 time = 940
* CHECK dout0_7 vdout0_7ck93 = 0 time = 940
* CHECK dout0_8 vdout0_8ck93 = 0 time = 940
* CHECK dout0_9 vdout0_9ck93 = 1.8 time = 940
* CHECK dout0_10 vdout0_10ck93 = 0 time = 940
* CHECK dout0_11 vdout0_11ck93 = 0 time = 940
* CHECK dout0_12 vdout0_12ck93 = 1.8 time = 940
* CHECK dout0_13 vdout0_13ck93 = 1.8 time = 940
* CHECK dout0_14 vdout0_14ck93 = 0 time = 940
* CHECK dout0_15 vdout0_15ck93 = 1.8 time = 940
* CHECK dout0_16 vdout0_16ck93 = 0 time = 940
* CHECK dout0_17 vdout0_17ck93 = 0 time = 940
* CHECK dout0_18 vdout0_18ck93 = 0 time = 940
* CHECK dout0_19 vdout0_19ck93 = 1.8 time = 940
* CHECK dout0_20 vdout0_20ck93 = 0 time = 940
* CHECK dout0_21 vdout0_21ck93 = 0 time = 940
* CHECK dout0_22 vdout0_22ck93 = 0 time = 940
* CHECK dout0_23 vdout0_23ck93 = 0 time = 940
* CHECK dout0_24 vdout0_24ck93 = 0 time = 940
* CHECK dout0_25 vdout0_25ck93 = 1.8 time = 940
* CHECK dout0_26 vdout0_26ck93 = 1.8 time = 940
* CHECK dout0_27 vdout0_27ck93 = 0 time = 940
* CHECK dout0_28 vdout0_28ck93 = 0 time = 940
* CHECK dout0_29 vdout0_29ck93 = 0 time = 940
* CHECK dout0_30 vdout0_30ck93 = 0 time = 940
* CHECK dout0_31 vdout0_31ck93 = 1.8 time = 940
* CHECK dout1_0 vdout1_0ck93 = 1.8 time = 940
* CHECK dout1_1 vdout1_1ck93 = 0 time = 940
* CHECK dout1_2 vdout1_2ck93 = 0 time = 940
* CHECK dout1_3 vdout1_3ck93 = 0 time = 940
* CHECK dout1_4 vdout1_4ck93 = 1.8 time = 940
* CHECK dout1_5 vdout1_5ck93 = 0 time = 940
* CHECK dout1_6 vdout1_6ck93 = 0 time = 940
* CHECK dout1_7 vdout1_7ck93 = 0 time = 940
* CHECK dout1_8 vdout1_8ck93 = 0 time = 940
* CHECK dout1_9 vdout1_9ck93 = 0 time = 940
* CHECK dout1_10 vdout1_10ck93 = 0 time = 940
* CHECK dout1_11 vdout1_11ck93 = 1.8 time = 940
* CHECK dout1_12 vdout1_12ck93 = 1.8 time = 940
* CHECK dout1_13 vdout1_13ck93 = 0 time = 940
* CHECK dout1_14 vdout1_14ck93 = 0 time = 940
* CHECK dout1_15 vdout1_15ck93 = 1.8 time = 940
* CHECK dout1_16 vdout1_16ck93 = 0 time = 940
* CHECK dout1_17 vdout1_17ck93 = 0 time = 940
* CHECK dout1_18 vdout1_18ck93 = 0 time = 940
* CHECK dout1_19 vdout1_19ck93 = 0 time = 940
* CHECK dout1_20 vdout1_20ck93 = 0 time = 940
* CHECK dout1_21 vdout1_21ck93 = 1.8 time = 940
* CHECK dout1_22 vdout1_22ck93 = 0 time = 940
* CHECK dout1_23 vdout1_23ck93 = 0 time = 940
* CHECK dout1_24 vdout1_24ck93 = 1.8 time = 940
* CHECK dout1_25 vdout1_25ck93 = 0 time = 940
* CHECK dout1_26 vdout1_26ck93 = 1.8 time = 940
* CHECK dout1_27 vdout1_27ck93 = 0 time = 940
* CHECK dout1_28 vdout1_28ck93 = 1.8 time = 940
* CHECK dout1_29 vdout1_29ck93 = 1.8 time = 940
* CHECK dout1_30 vdout1_30ck93 = 0 time = 940
* CHECK dout1_31 vdout1_31ck93 = 1.8 time = 940
* CHECK dout0_0 vdout0_0ck94 = 0 time = 950
* CHECK dout0_1 vdout0_1ck94 = 1.8 time = 950
* CHECK dout0_2 vdout0_2ck94 = 0 time = 950
* CHECK dout0_3 vdout0_3ck94 = 0 time = 950
* CHECK dout0_4 vdout0_4ck94 = 0 time = 950
* CHECK dout0_5 vdout0_5ck94 = 0 time = 950
* CHECK dout0_6 vdout0_6ck94 = 1.8 time = 950
* CHECK dout0_7 vdout0_7ck94 = 0 time = 950
* CHECK dout0_8 vdout0_8ck94 = 1.8 time = 950
* CHECK dout0_9 vdout0_9ck94 = 1.8 time = 950
* CHECK dout0_10 vdout0_10ck94 = 1.8 time = 950
* CHECK dout0_11 vdout0_11ck94 = 1.8 time = 950
* CHECK dout0_12 vdout0_12ck94 = 1.8 time = 950
* CHECK dout0_13 vdout0_13ck94 = 0 time = 950
* CHECK dout0_14 vdout0_14ck94 = 0 time = 950
* CHECK dout0_15 vdout0_15ck94 = 1.8 time = 950
* CHECK dout0_16 vdout0_16ck94 = 0 time = 950
* CHECK dout0_17 vdout0_17ck94 = 0 time = 950
* CHECK dout0_18 vdout0_18ck94 = 0 time = 950
* CHECK dout0_19 vdout0_19ck94 = 1.8 time = 950
* CHECK dout0_20 vdout0_20ck94 = 1.8 time = 950
* CHECK dout0_21 vdout0_21ck94 = 0 time = 950
* CHECK dout0_22 vdout0_22ck94 = 1.8 time = 950
* CHECK dout0_23 vdout0_23ck94 = 0 time = 950
* CHECK dout0_24 vdout0_24ck94 = 1.8 time = 950
* CHECK dout0_25 vdout0_25ck94 = 0 time = 950
* CHECK dout0_26 vdout0_26ck94 = 0 time = 950
* CHECK dout0_27 vdout0_27ck94 = 1.8 time = 950
* CHECK dout0_28 vdout0_28ck94 = 0 time = 950
* CHECK dout0_29 vdout0_29ck94 = 1.8 time = 950
* CHECK dout0_30 vdout0_30ck94 = 0 time = 950
* CHECK dout0_31 vdout0_31ck94 = 0 time = 950
* CHECK dout1_0 vdout1_0ck94 = 1.8 time = 950
* CHECK dout1_1 vdout1_1ck94 = 1.8 time = 950
* CHECK dout1_2 vdout1_2ck94 = 0 time = 950
* CHECK dout1_3 vdout1_3ck94 = 1.8 time = 950
* CHECK dout1_4 vdout1_4ck94 = 0 time = 950
* CHECK dout1_5 vdout1_5ck94 = 1.8 time = 950
* CHECK dout1_6 vdout1_6ck94 = 1.8 time = 950
* CHECK dout1_7 vdout1_7ck94 = 0 time = 950
* CHECK dout1_8 vdout1_8ck94 = 1.8 time = 950
* CHECK dout1_9 vdout1_9ck94 = 0 time = 950
* CHECK dout1_10 vdout1_10ck94 = 1.8 time = 950
* CHECK dout1_11 vdout1_11ck94 = 1.8 time = 950
* CHECK dout1_12 vdout1_12ck94 = 1.8 time = 950
* CHECK dout1_13 vdout1_13ck94 = 1.8 time = 950
* CHECK dout1_14 vdout1_14ck94 = 0 time = 950
* CHECK dout1_15 vdout1_15ck94 = 1.8 time = 950
* CHECK dout1_16 vdout1_16ck94 = 1.8 time = 950
* CHECK dout1_17 vdout1_17ck94 = 1.8 time = 950
* CHECK dout1_18 vdout1_18ck94 = 0 time = 950
* CHECK dout1_19 vdout1_19ck94 = 0 time = 950
* CHECK dout1_20 vdout1_20ck94 = 1.8 time = 950
* CHECK dout1_21 vdout1_21ck94 = 0 time = 950
* CHECK dout1_22 vdout1_22ck94 = 0 time = 950
* CHECK dout1_23 vdout1_23ck94 = 0 time = 950
* CHECK dout1_24 vdout1_24ck94 = 0 time = 950
* CHECK dout1_25 vdout1_25ck94 = 0 time = 950
* CHECK dout1_26 vdout1_26ck94 = 1.8 time = 950
* CHECK dout1_27 vdout1_27ck94 = 1.8 time = 950
* CHECK dout1_28 vdout1_28ck94 = 0 time = 950
* CHECK dout1_29 vdout1_29ck94 = 1.8 time = 950
* CHECK dout1_30 vdout1_30ck94 = 0 time = 950
* CHECK dout1_31 vdout1_31ck94 = 0 time = 950
* CHECK dout0_0 vdout0_0ck95 = 1.8 time = 960
* CHECK dout0_1 vdout0_1ck95 = 0 time = 960
* CHECK dout0_2 vdout0_2ck95 = 0 time = 960
* CHECK dout0_3 vdout0_3ck95 = 0 time = 960
* CHECK dout0_4 vdout0_4ck95 = 1.8 time = 960
* CHECK dout0_5 vdout0_5ck95 = 0 time = 960
* CHECK dout0_6 vdout0_6ck95 = 0 time = 960
* CHECK dout0_7 vdout0_7ck95 = 0 time = 960
* CHECK dout0_8 vdout0_8ck95 = 0 time = 960
* CHECK dout0_9 vdout0_9ck95 = 0 time = 960
* CHECK dout0_10 vdout0_10ck95 = 0 time = 960
* CHECK dout0_11 vdout0_11ck95 = 1.8 time = 960
* CHECK dout0_12 vdout0_12ck95 = 1.8 time = 960
* CHECK dout0_13 vdout0_13ck95 = 0 time = 960
* CHECK dout0_14 vdout0_14ck95 = 0 time = 960
* CHECK dout0_15 vdout0_15ck95 = 1.8 time = 960
* CHECK dout0_16 vdout0_16ck95 = 0 time = 960
* CHECK dout0_17 vdout0_17ck95 = 0 time = 960
* CHECK dout0_18 vdout0_18ck95 = 0 time = 960
* CHECK dout0_19 vdout0_19ck95 = 0 time = 960
* CHECK dout0_20 vdout0_20ck95 = 0 time = 960
* CHECK dout0_21 vdout0_21ck95 = 1.8 time = 960
* CHECK dout0_22 vdout0_22ck95 = 0 time = 960
* CHECK dout0_23 vdout0_23ck95 = 0 time = 960
* CHECK dout0_24 vdout0_24ck95 = 1.8 time = 960
* CHECK dout0_25 vdout0_25ck95 = 0 time = 960
* CHECK dout0_26 vdout0_26ck95 = 1.8 time = 960
* CHECK dout0_27 vdout0_27ck95 = 0 time = 960
* CHECK dout0_28 vdout0_28ck95 = 1.8 time = 960
* CHECK dout0_29 vdout0_29ck95 = 1.8 time = 960
* CHECK dout0_30 vdout0_30ck95 = 0 time = 960
* CHECK dout0_31 vdout0_31ck95 = 1.8 time = 960
* CHECK dout0_0 vdout0_0ck96 = 1.8 time = 970
* CHECK dout0_1 vdout0_1ck96 = 1.8 time = 970
* CHECK dout0_2 vdout0_2ck96 = 0 time = 970
* CHECK dout0_3 vdout0_3ck96 = 1.8 time = 970
* CHECK dout0_4 vdout0_4ck96 = 0 time = 970
* CHECK dout0_5 vdout0_5ck96 = 1.8 time = 970
* CHECK dout0_6 vdout0_6ck96 = 1.8 time = 970
* CHECK dout0_7 vdout0_7ck96 = 0 time = 970
* CHECK dout0_8 vdout0_8ck96 = 1.8 time = 970
* CHECK dout0_9 vdout0_9ck96 = 0 time = 970
* CHECK dout0_10 vdout0_10ck96 = 1.8 time = 970
* CHECK dout0_11 vdout0_11ck96 = 1.8 time = 970
* CHECK dout0_12 vdout0_12ck96 = 1.8 time = 970
* CHECK dout0_13 vdout0_13ck96 = 1.8 time = 970
* CHECK dout0_14 vdout0_14ck96 = 0 time = 970
* CHECK dout0_15 vdout0_15ck96 = 1.8 time = 970
* CHECK dout0_16 vdout0_16ck96 = 1.8 time = 970
* CHECK dout0_17 vdout0_17ck96 = 1.8 time = 970
* CHECK dout0_18 vdout0_18ck96 = 0 time = 970
* CHECK dout0_19 vdout0_19ck96 = 0 time = 970
* CHECK dout0_20 vdout0_20ck96 = 1.8 time = 970
* CHECK dout0_21 vdout0_21ck96 = 0 time = 970
* CHECK dout0_22 vdout0_22ck96 = 0 time = 970
* CHECK dout0_23 vdout0_23ck96 = 0 time = 970
* CHECK dout0_24 vdout0_24ck96 = 0 time = 970
* CHECK dout0_25 vdout0_25ck96 = 0 time = 970
* CHECK dout0_26 vdout0_26ck96 = 1.8 time = 970
* CHECK dout0_27 vdout0_27ck96 = 1.8 time = 970
* CHECK dout0_28 vdout0_28ck96 = 0 time = 970
* CHECK dout0_29 vdout0_29ck96 = 1.8 time = 970
* CHECK dout0_30 vdout0_30ck96 = 0 time = 970
* CHECK dout0_31 vdout0_31ck96 = 0 time = 970
* CHECK dout1_0 vdout1_0ck98 = 1.8 time = 990
* CHECK dout1_1 vdout1_1ck98 = 1.8 time = 990
* CHECK dout1_2 vdout1_2ck98 = 0 time = 990
* CHECK dout1_3 vdout1_3ck98 = 1.8 time = 990
* CHECK dout1_4 vdout1_4ck98 = 0 time = 990
* CHECK dout1_5 vdout1_5ck98 = 1.8 time = 990
* CHECK dout1_6 vdout1_6ck98 = 1.8 time = 990
* CHECK dout1_7 vdout1_7ck98 = 0 time = 990
* CHECK dout1_8 vdout1_8ck98 = 1.8 time = 990
* CHECK dout1_9 vdout1_9ck98 = 0 time = 990
* CHECK dout1_10 vdout1_10ck98 = 1.8 time = 990
* CHECK dout1_11 vdout1_11ck98 = 1.8 time = 990
* CHECK dout1_12 vdout1_12ck98 = 1.8 time = 990
* CHECK dout1_13 vdout1_13ck98 = 1.8 time = 990
* CHECK dout1_14 vdout1_14ck98 = 0 time = 990
* CHECK dout1_15 vdout1_15ck98 = 1.8 time = 990
* CHECK dout1_16 vdout1_16ck98 = 1.8 time = 990
* CHECK dout1_17 vdout1_17ck98 = 1.8 time = 990
* CHECK dout1_18 vdout1_18ck98 = 0 time = 990
* CHECK dout1_19 vdout1_19ck98 = 0 time = 990
* CHECK dout1_20 vdout1_20ck98 = 1.8 time = 990
* CHECK dout1_21 vdout1_21ck98 = 0 time = 990
* CHECK dout1_22 vdout1_22ck98 = 0 time = 990
* CHECK dout1_23 vdout1_23ck98 = 0 time = 990
* CHECK dout1_24 vdout1_24ck98 = 0 time = 990
* CHECK dout1_25 vdout1_25ck98 = 0 time = 990
* CHECK dout1_26 vdout1_26ck98 = 1.8 time = 990
* CHECK dout1_27 vdout1_27ck98 = 1.8 time = 990
* CHECK dout1_28 vdout1_28ck98 = 0 time = 990
* CHECK dout1_29 vdout1_29ck98 = 1.8 time = 990
* CHECK dout1_30 vdout1_30ck98 = 0 time = 990
* CHECK dout1_31 vdout1_31ck98 = 0 time = 990
* CHECK dout1_0 vdout1_0ck99 = 1.8 time = 1000
* CHECK dout1_1 vdout1_1ck99 = 0 time = 1000
* CHECK dout1_2 vdout1_2ck99 = 1.8 time = 1000
* CHECK dout1_3 vdout1_3ck99 = 1.8 time = 1000
* CHECK dout1_4 vdout1_4ck99 = 0 time = 1000
* CHECK dout1_5 vdout1_5ck99 = 0 time = 1000
* CHECK dout1_6 vdout1_6ck99 = 0 time = 1000
* CHECK dout1_7 vdout1_7ck99 = 0 time = 1000
* CHECK dout1_8 vdout1_8ck99 = 0 time = 1000
* CHECK dout1_9 vdout1_9ck99 = 0 time = 1000
* CHECK dout1_10 vdout1_10ck99 = 0 time = 1000
* CHECK dout1_11 vdout1_11ck99 = 1.8 time = 1000
* CHECK dout1_12 vdout1_12ck99 = 0 time = 1000
* CHECK dout1_13 vdout1_13ck99 = 0 time = 1000
* CHECK dout1_14 vdout1_14ck99 = 0 time = 1000
* CHECK dout1_15 vdout1_15ck99 = 0 time = 1000
* CHECK dout1_16 vdout1_16ck99 = 0 time = 1000
* CHECK dout1_17 vdout1_17ck99 = 1.8 time = 1000
* CHECK dout1_18 vdout1_18ck99 = 0 time = 1000
* CHECK dout1_19 vdout1_19ck99 = 1.8 time = 1000
* CHECK dout1_20 vdout1_20ck99 = 0 time = 1000
* CHECK dout1_21 vdout1_21ck99 = 1.8 time = 1000
* CHECK dout1_22 vdout1_22ck99 = 0 time = 1000
* CHECK dout1_23 vdout1_23ck99 = 1.8 time = 1000
* CHECK dout1_24 vdout1_24ck99 = 0 time = 1000
* CHECK dout1_25 vdout1_25ck99 = 0 time = 1000
* CHECK dout1_26 vdout1_26ck99 = 0 time = 1000
* CHECK dout1_27 vdout1_27ck99 = 0 time = 1000
* CHECK dout1_28 vdout1_28ck99 = 0 time = 1000
* CHECK dout1_29 vdout1_29ck99 = 1.8 time = 1000
* CHECK dout1_30 vdout1_30ck99 = 0 time = 1000
* CHECK dout1_31 vdout1_31ck99 = 0 time = 1000
* CHECK dout1_0 vdout1_0ck104 = 0 time = 1050
* CHECK dout1_1 vdout1_1ck104 = 1.8 time = 1050
* CHECK dout1_2 vdout1_2ck104 = 0 time = 1050
* CHECK dout1_3 vdout1_3ck104 = 0 time = 1050
* CHECK dout1_4 vdout1_4ck104 = 1.8 time = 1050
* CHECK dout1_5 vdout1_5ck104 = 1.8 time = 1050
* CHECK dout1_6 vdout1_6ck104 = 1.8 time = 1050
* CHECK dout1_7 vdout1_7ck104 = 1.8 time = 1050
* CHECK dout1_8 vdout1_8ck104 = 0 time = 1050
* CHECK dout1_9 vdout1_9ck104 = 1.8 time = 1050
* CHECK dout1_10 vdout1_10ck104 = 1.8 time = 1050
* CHECK dout1_11 vdout1_11ck104 = 0 time = 1050
* CHECK dout1_12 vdout1_12ck104 = 1.8 time = 1050
* CHECK dout1_13 vdout1_13ck104 = 0 time = 1050
* CHECK dout1_14 vdout1_14ck104 = 1.8 time = 1050
* CHECK dout1_15 vdout1_15ck104 = 0 time = 1050
* CHECK dout1_16 vdout1_16ck104 = 1.8 time = 1050
* CHECK dout1_17 vdout1_17ck104 = 1.8 time = 1050
* CHECK dout1_18 vdout1_18ck104 = 1.8 time = 1050
* CHECK dout1_19 vdout1_19ck104 = 0 time = 1050
* CHECK dout1_20 vdout1_20ck104 = 1.8 time = 1050
* CHECK dout1_21 vdout1_21ck104 = 1.8 time = 1050
* CHECK dout1_22 vdout1_22ck104 = 0 time = 1050
* CHECK dout1_23 vdout1_23ck104 = 0 time = 1050
* CHECK dout1_24 vdout1_24ck104 = 1.8 time = 1050
* CHECK dout1_25 vdout1_25ck104 = 0 time = 1050
* CHECK dout1_26 vdout1_26ck104 = 1.8 time = 1050
* CHECK dout1_27 vdout1_27ck104 = 1.8 time = 1050
* CHECK dout1_28 vdout1_28ck104 = 0 time = 1050
* CHECK dout1_29 vdout1_29ck104 = 0 time = 1050
* CHECK dout1_30 vdout1_30ck104 = 1.8 time = 1050
* CHECK dout1_31 vdout1_31ck104 = 0 time = 1050
* CHECK dout0_0 vdout0_0ck105 = 1.8 time = 1060
* CHECK dout0_1 vdout0_1ck105 = 0 time = 1060
* CHECK dout0_2 vdout0_2ck105 = 1.8 time = 1060
* CHECK dout0_3 vdout0_3ck105 = 1.8 time = 1060
* CHECK dout0_4 vdout0_4ck105 = 0 time = 1060
* CHECK dout0_5 vdout0_5ck105 = 0 time = 1060
* CHECK dout0_6 vdout0_6ck105 = 0 time = 1060
* CHECK dout0_7 vdout0_7ck105 = 0 time = 1060
* CHECK dout0_8 vdout0_8ck105 = 0 time = 1060
* CHECK dout0_9 vdout0_9ck105 = 0 time = 1060
* CHECK dout0_10 vdout0_10ck105 = 0 time = 1060
* CHECK dout0_11 vdout0_11ck105 = 1.8 time = 1060
* CHECK dout0_12 vdout0_12ck105 = 0 time = 1060
* CHECK dout0_13 vdout0_13ck105 = 0 time = 1060
* CHECK dout0_14 vdout0_14ck105 = 0 time = 1060
* CHECK dout0_15 vdout0_15ck105 = 0 time = 1060
* CHECK dout0_16 vdout0_16ck105 = 0 time = 1060
* CHECK dout0_17 vdout0_17ck105 = 1.8 time = 1060
* CHECK dout0_18 vdout0_18ck105 = 0 time = 1060
* CHECK dout0_19 vdout0_19ck105 = 1.8 time = 1060
* CHECK dout0_20 vdout0_20ck105 = 0 time = 1060
* CHECK dout0_21 vdout0_21ck105 = 1.8 time = 1060
* CHECK dout0_22 vdout0_22ck105 = 0 time = 1060
* CHECK dout0_23 vdout0_23ck105 = 1.8 time = 1060
* CHECK dout0_24 vdout0_24ck105 = 0 time = 1060
* CHECK dout0_25 vdout0_25ck105 = 0 time = 1060
* CHECK dout0_26 vdout0_26ck105 = 0 time = 1060
* CHECK dout0_27 vdout0_27ck105 = 0 time = 1060
* CHECK dout0_28 vdout0_28ck105 = 0 time = 1060
* CHECK dout0_29 vdout0_29ck105 = 1.8 time = 1060
* CHECK dout0_30 vdout0_30ck105 = 0 time = 1060
* CHECK dout0_31 vdout0_31ck105 = 0 time = 1060
* CHECK dout0_0 vdout0_0ck106 = 1.8 time = 1070
* CHECK dout0_1 vdout0_1ck106 = 0 time = 1070
* CHECK dout0_2 vdout0_2ck106 = 0 time = 1070
* CHECK dout0_3 vdout0_3ck106 = 0 time = 1070
* CHECK dout0_4 vdout0_4ck106 = 0 time = 1070
* CHECK dout0_5 vdout0_5ck106 = 0 time = 1070
* CHECK dout0_6 vdout0_6ck106 = 0 time = 1070
* CHECK dout0_7 vdout0_7ck106 = 0 time = 1070
* CHECK dout0_8 vdout0_8ck106 = 0 time = 1070
* CHECK dout0_9 vdout0_9ck106 = 1.8 time = 1070
* CHECK dout0_10 vdout0_10ck106 = 0 time = 1070
* CHECK dout0_11 vdout0_11ck106 = 0 time = 1070
* CHECK dout0_12 vdout0_12ck106 = 1.8 time = 1070
* CHECK dout0_13 vdout0_13ck106 = 1.8 time = 1070
* CHECK dout0_14 vdout0_14ck106 = 0 time = 1070
* CHECK dout0_15 vdout0_15ck106 = 1.8 time = 1070
* CHECK dout0_16 vdout0_16ck106 = 0 time = 1070
* CHECK dout0_17 vdout0_17ck106 = 0 time = 1070
* CHECK dout0_18 vdout0_18ck106 = 0 time = 1070
* CHECK dout0_19 vdout0_19ck106 = 1.8 time = 1070
* CHECK dout0_20 vdout0_20ck106 = 0 time = 1070
* CHECK dout0_21 vdout0_21ck106 = 0 time = 1070
* CHECK dout0_22 vdout0_22ck106 = 0 time = 1070
* CHECK dout0_23 vdout0_23ck106 = 0 time = 1070
* CHECK dout0_24 vdout0_24ck106 = 0 time = 1070
* CHECK dout0_25 vdout0_25ck106 = 1.8 time = 1070
* CHECK dout0_26 vdout0_26ck106 = 1.8 time = 1070
* CHECK dout0_27 vdout0_27ck106 = 0 time = 1070
* CHECK dout0_28 vdout0_28ck106 = 0 time = 1070
* CHECK dout0_29 vdout0_29ck106 = 0 time = 1070
* CHECK dout0_30 vdout0_30ck106 = 0 time = 1070
* CHECK dout0_31 vdout0_31ck106 = 1.8 time = 1070
* CHECK dout1_0 vdout1_0ck106 = 1.8 time = 1070
* CHECK dout1_1 vdout1_1ck106 = 0 time = 1070
* CHECK dout1_2 vdout1_2ck106 = 0 time = 1070
* CHECK dout1_3 vdout1_3ck106 = 0 time = 1070
* CHECK dout1_4 vdout1_4ck106 = 1.8 time = 1070
* CHECK dout1_5 vdout1_5ck106 = 0 time = 1070
* CHECK dout1_6 vdout1_6ck106 = 1.8 time = 1070
* CHECK dout1_7 vdout1_7ck106 = 0 time = 1070
* CHECK dout1_8 vdout1_8ck106 = 0 time = 1070
* CHECK dout1_9 vdout1_9ck106 = 1.8 time = 1070
* CHECK dout1_10 vdout1_10ck106 = 1.8 time = 1070
* CHECK dout1_11 vdout1_11ck106 = 1.8 time = 1070
* CHECK dout1_12 vdout1_12ck106 = 1.8 time = 1070
* CHECK dout1_13 vdout1_13ck106 = 1.8 time = 1070
* CHECK dout1_14 vdout1_14ck106 = 0 time = 1070
* CHECK dout1_15 vdout1_15ck106 = 1.8 time = 1070
* CHECK dout1_16 vdout1_16ck106 = 1.8 time = 1070
* CHECK dout1_17 vdout1_17ck106 = 1.8 time = 1070
* CHECK dout1_18 vdout1_18ck106 = 0 time = 1070
* CHECK dout1_19 vdout1_19ck106 = 0 time = 1070
* CHECK dout1_20 vdout1_20ck106 = 1.8 time = 1070
* CHECK dout1_21 vdout1_21ck106 = 1.8 time = 1070
* CHECK dout1_22 vdout1_22ck106 = 1.8 time = 1070
* CHECK dout1_23 vdout1_23ck106 = 0 time = 1070
* CHECK dout1_24 vdout1_24ck106 = 0 time = 1070
* CHECK dout1_25 vdout1_25ck106 = 0 time = 1070
* CHECK dout1_26 vdout1_26ck106 = 1.8 time = 1070
* CHECK dout1_27 vdout1_27ck106 = 1.8 time = 1070
* CHECK dout1_28 vdout1_28ck106 = 1.8 time = 1070
* CHECK dout1_29 vdout1_29ck106 = 0 time = 1070
* CHECK dout1_30 vdout1_30ck106 = 0 time = 1070
* CHECK dout1_31 vdout1_31ck106 = 0 time = 1070
* CHECK dout0_0 vdout0_0ck107 = 1.8 time = 1080
* CHECK dout0_1 vdout0_1ck107 = 1.8 time = 1080
* CHECK dout0_2 vdout0_2ck107 = 0 time = 1080
* CHECK dout0_3 vdout0_3ck107 = 1.8 time = 1080
* CHECK dout0_4 vdout0_4ck107 = 0 time = 1080
* CHECK dout0_5 vdout0_5ck107 = 1.8 time = 1080
* CHECK dout0_6 vdout0_6ck107 = 1.8 time = 1080
* CHECK dout0_7 vdout0_7ck107 = 0 time = 1080
* CHECK dout0_8 vdout0_8ck107 = 1.8 time = 1080
* CHECK dout0_9 vdout0_9ck107 = 0 time = 1080
* CHECK dout0_10 vdout0_10ck107 = 1.8 time = 1080
* CHECK dout0_11 vdout0_11ck107 = 1.8 time = 1080
* CHECK dout0_12 vdout0_12ck107 = 1.8 time = 1080
* CHECK dout0_13 vdout0_13ck107 = 1.8 time = 1080
* CHECK dout0_14 vdout0_14ck107 = 0 time = 1080
* CHECK dout0_15 vdout0_15ck107 = 1.8 time = 1080
* CHECK dout0_16 vdout0_16ck107 = 1.8 time = 1080
* CHECK dout0_17 vdout0_17ck107 = 1.8 time = 1080
* CHECK dout0_18 vdout0_18ck107 = 0 time = 1080
* CHECK dout0_19 vdout0_19ck107 = 0 time = 1080
* CHECK dout0_20 vdout0_20ck107 = 1.8 time = 1080
* CHECK dout0_21 vdout0_21ck107 = 0 time = 1080
* CHECK dout0_22 vdout0_22ck107 = 0 time = 1080
* CHECK dout0_23 vdout0_23ck107 = 0 time = 1080
* CHECK dout0_24 vdout0_24ck107 = 0 time = 1080
* CHECK dout0_25 vdout0_25ck107 = 0 time = 1080
* CHECK dout0_26 vdout0_26ck107 = 1.8 time = 1080
* CHECK dout0_27 vdout0_27ck107 = 1.8 time = 1080
* CHECK dout0_28 vdout0_28ck107 = 0 time = 1080
* CHECK dout0_29 vdout0_29ck107 = 1.8 time = 1080
* CHECK dout0_30 vdout0_30ck107 = 0 time = 1080
* CHECK dout0_31 vdout0_31ck107 = 0 time = 1080
* CHECK dout0_0 vdout0_0ck108 = 1.8 time = 1090
* CHECK dout0_1 vdout0_1ck108 = 0 time = 1090
* CHECK dout0_2 vdout0_2ck108 = 1.8 time = 1090
* CHECK dout0_3 vdout0_3ck108 = 1.8 time = 1090
* CHECK dout0_4 vdout0_4ck108 = 0 time = 1090
* CHECK dout0_5 vdout0_5ck108 = 0 time = 1090
* CHECK dout0_6 vdout0_6ck108 = 0 time = 1090
* CHECK dout0_7 vdout0_7ck108 = 0 time = 1090
* CHECK dout0_8 vdout0_8ck108 = 0 time = 1090
* CHECK dout0_9 vdout0_9ck108 = 0 time = 1090
* CHECK dout0_10 vdout0_10ck108 = 0 time = 1090
* CHECK dout0_11 vdout0_11ck108 = 1.8 time = 1090
* CHECK dout0_12 vdout0_12ck108 = 0 time = 1090
* CHECK dout0_13 vdout0_13ck108 = 0 time = 1090
* CHECK dout0_14 vdout0_14ck108 = 0 time = 1090
* CHECK dout0_15 vdout0_15ck108 = 0 time = 1090
* CHECK dout0_16 vdout0_16ck108 = 0 time = 1090
* CHECK dout0_17 vdout0_17ck108 = 1.8 time = 1090
* CHECK dout0_18 vdout0_18ck108 = 0 time = 1090
* CHECK dout0_19 vdout0_19ck108 = 1.8 time = 1090
* CHECK dout0_20 vdout0_20ck108 = 0 time = 1090
* CHECK dout0_21 vdout0_21ck108 = 1.8 time = 1090
* CHECK dout0_22 vdout0_22ck108 = 0 time = 1090
* CHECK dout0_23 vdout0_23ck108 = 1.8 time = 1090
* CHECK dout0_24 vdout0_24ck108 = 0 time = 1090
* CHECK dout0_25 vdout0_25ck108 = 0 time = 1090
* CHECK dout0_26 vdout0_26ck108 = 0 time = 1090
* CHECK dout0_27 vdout0_27ck108 = 0 time = 1090
* CHECK dout0_28 vdout0_28ck108 = 0 time = 1090
* CHECK dout0_29 vdout0_29ck108 = 1.8 time = 1090
* CHECK dout0_30 vdout0_30ck108 = 0 time = 1090
* CHECK dout0_31 vdout0_31ck108 = 0 time = 1090
* CHECK dout1_0 vdout1_0ck108 = 1.8 time = 1090
* CHECK dout1_1 vdout1_1ck108 = 0 time = 1090
* CHECK dout1_2 vdout1_2ck108 = 0 time = 1090
* CHECK dout1_3 vdout1_3ck108 = 0 time = 1090
* CHECK dout1_4 vdout1_4ck108 = 0 time = 1090
* CHECK dout1_5 vdout1_5ck108 = 0 time = 1090
* CHECK dout1_6 vdout1_6ck108 = 0 time = 1090
* CHECK dout1_7 vdout1_7ck108 = 0 time = 1090
* CHECK dout1_8 vdout1_8ck108 = 0 time = 1090
* CHECK dout1_9 vdout1_9ck108 = 1.8 time = 1090
* CHECK dout1_10 vdout1_10ck108 = 0 time = 1090
* CHECK dout1_11 vdout1_11ck108 = 0 time = 1090
* CHECK dout1_12 vdout1_12ck108 = 1.8 time = 1090
* CHECK dout1_13 vdout1_13ck108 = 1.8 time = 1090
* CHECK dout1_14 vdout1_14ck108 = 0 time = 1090
* CHECK dout1_15 vdout1_15ck108 = 1.8 time = 1090
* CHECK dout1_16 vdout1_16ck108 = 0 time = 1090
* CHECK dout1_17 vdout1_17ck108 = 0 time = 1090
* CHECK dout1_18 vdout1_18ck108 = 0 time = 1090
* CHECK dout1_19 vdout1_19ck108 = 1.8 time = 1090
* CHECK dout1_20 vdout1_20ck108 = 0 time = 1090
* CHECK dout1_21 vdout1_21ck108 = 0 time = 1090
* CHECK dout1_22 vdout1_22ck108 = 0 time = 1090
* CHECK dout1_23 vdout1_23ck108 = 0 time = 1090
* CHECK dout1_24 vdout1_24ck108 = 0 time = 1090
* CHECK dout1_25 vdout1_25ck108 = 1.8 time = 1090
* CHECK dout1_26 vdout1_26ck108 = 1.8 time = 1090
* CHECK dout1_27 vdout1_27ck108 = 0 time = 1090
* CHECK dout1_28 vdout1_28ck108 = 0 time = 1090
* CHECK dout1_29 vdout1_29ck108 = 0 time = 1090
* CHECK dout1_30 vdout1_30ck108 = 0 time = 1090
* CHECK dout1_31 vdout1_31ck108 = 1.8 time = 1090
* CHECK dout0_0 vdout0_0ck109 = 0 time = 1100
* CHECK dout0_1 vdout0_1ck109 = 1.8 time = 1100
* CHECK dout0_2 vdout0_2ck109 = 0 time = 1100
* CHECK dout0_3 vdout0_3ck109 = 0 time = 1100
* CHECK dout0_4 vdout0_4ck109 = 1.8 time = 1100
* CHECK dout0_5 vdout0_5ck109 = 1.8 time = 1100
* CHECK dout0_6 vdout0_6ck109 = 1.8 time = 1100
* CHECK dout0_7 vdout0_7ck109 = 1.8 time = 1100
* CHECK dout0_8 vdout0_8ck109 = 0 time = 1100
* CHECK dout0_9 vdout0_9ck109 = 1.8 time = 1100
* CHECK dout0_10 vdout0_10ck109 = 1.8 time = 1100
* CHECK dout0_11 vdout0_11ck109 = 0 time = 1100
* CHECK dout0_12 vdout0_12ck109 = 1.8 time = 1100
* CHECK dout0_13 vdout0_13ck109 = 0 time = 1100
* CHECK dout0_14 vdout0_14ck109 = 1.8 time = 1100
* CHECK dout0_15 vdout0_15ck109 = 0 time = 1100
* CHECK dout0_16 vdout0_16ck109 = 1.8 time = 1100
* CHECK dout0_17 vdout0_17ck109 = 1.8 time = 1100
* CHECK dout0_18 vdout0_18ck109 = 1.8 time = 1100
* CHECK dout0_19 vdout0_19ck109 = 0 time = 1100
* CHECK dout0_20 vdout0_20ck109 = 1.8 time = 1100
* CHECK dout0_21 vdout0_21ck109 = 1.8 time = 1100
* CHECK dout0_22 vdout0_22ck109 = 0 time = 1100
* CHECK dout0_23 vdout0_23ck109 = 0 time = 1100
* CHECK dout0_24 vdout0_24ck109 = 1.8 time = 1100
* CHECK dout0_25 vdout0_25ck109 = 0 time = 1100
* CHECK dout0_26 vdout0_26ck109 = 1.8 time = 1100
* CHECK dout0_27 vdout0_27ck109 = 1.8 time = 1100
* CHECK dout0_28 vdout0_28ck109 = 0 time = 1100
* CHECK dout0_29 vdout0_29ck109 = 0 time = 1100
* CHECK dout0_30 vdout0_30ck109 = 1.8 time = 1100
* CHECK dout0_31 vdout0_31ck109 = 0 time = 1100
* CHECK dout1_0 vdout1_0ck110 = 1.8 time = 1110
* CHECK dout1_1 vdout1_1ck110 = 0 time = 1110
* CHECK dout1_2 vdout1_2ck110 = 0 time = 1110
* CHECK dout1_3 vdout1_3ck110 = 0 time = 1110
* CHECK dout1_4 vdout1_4ck110 = 0 time = 1110
* CHECK dout1_5 vdout1_5ck110 = 0 time = 1110
* CHECK dout1_6 vdout1_6ck110 = 0 time = 1110
* CHECK dout1_7 vdout1_7ck110 = 0 time = 1110
* CHECK dout1_8 vdout1_8ck110 = 0 time = 1110
* CHECK dout1_9 vdout1_9ck110 = 1.8 time = 1110
* CHECK dout1_10 vdout1_10ck110 = 0 time = 1110
* CHECK dout1_11 vdout1_11ck110 = 0 time = 1110
* CHECK dout1_12 vdout1_12ck110 = 1.8 time = 1110
* CHECK dout1_13 vdout1_13ck110 = 1.8 time = 1110
* CHECK dout1_14 vdout1_14ck110 = 0 time = 1110
* CHECK dout1_15 vdout1_15ck110 = 1.8 time = 1110
* CHECK dout1_16 vdout1_16ck110 = 0 time = 1110
* CHECK dout1_17 vdout1_17ck110 = 0 time = 1110
* CHECK dout1_18 vdout1_18ck110 = 0 time = 1110
* CHECK dout1_19 vdout1_19ck110 = 1.8 time = 1110
* CHECK dout1_20 vdout1_20ck110 = 0 time = 1110
* CHECK dout1_21 vdout1_21ck110 = 0 time = 1110
* CHECK dout1_22 vdout1_22ck110 = 0 time = 1110
* CHECK dout1_23 vdout1_23ck110 = 0 time = 1110
* CHECK dout1_24 vdout1_24ck110 = 0 time = 1110
* CHECK dout1_25 vdout1_25ck110 = 1.8 time = 1110
* CHECK dout1_26 vdout1_26ck110 = 1.8 time = 1110
* CHECK dout1_27 vdout1_27ck110 = 0 time = 1110
* CHECK dout1_28 vdout1_28ck110 = 0 time = 1110
* CHECK dout1_29 vdout1_29ck110 = 0 time = 1110
* CHECK dout1_30 vdout1_30ck110 = 0 time = 1110
* CHECK dout1_31 vdout1_31ck110 = 1.8 time = 1110
* CHECK dout0_0 vdout0_0ck111 = 1.8 time = 1120
* CHECK dout0_1 vdout0_1ck111 = 0 time = 1120
* CHECK dout0_2 vdout0_2ck111 = 0 time = 1120
* CHECK dout0_3 vdout0_3ck111 = 0 time = 1120
* CHECK dout0_4 vdout0_4ck111 = 0 time = 1120
* CHECK dout0_5 vdout0_5ck111 = 0 time = 1120
* CHECK dout0_6 vdout0_6ck111 = 0 time = 1120
* CHECK dout0_7 vdout0_7ck111 = 0 time = 1120
* CHECK dout0_8 vdout0_8ck111 = 0 time = 1120
* CHECK dout0_9 vdout0_9ck111 = 1.8 time = 1120
* CHECK dout0_10 vdout0_10ck111 = 0 time = 1120
* CHECK dout0_11 vdout0_11ck111 = 0 time = 1120
* CHECK dout0_12 vdout0_12ck111 = 1.8 time = 1120
* CHECK dout0_13 vdout0_13ck111 = 1.8 time = 1120
* CHECK dout0_14 vdout0_14ck111 = 0 time = 1120
* CHECK dout0_15 vdout0_15ck111 = 1.8 time = 1120
* CHECK dout0_16 vdout0_16ck111 = 0 time = 1120
* CHECK dout0_17 vdout0_17ck111 = 0 time = 1120
* CHECK dout0_18 vdout0_18ck111 = 0 time = 1120
* CHECK dout0_19 vdout0_19ck111 = 1.8 time = 1120
* CHECK dout0_20 vdout0_20ck111 = 0 time = 1120
* CHECK dout0_21 vdout0_21ck111 = 0 time = 1120
* CHECK dout0_22 vdout0_22ck111 = 0 time = 1120
* CHECK dout0_23 vdout0_23ck111 = 0 time = 1120
* CHECK dout0_24 vdout0_24ck111 = 0 time = 1120
* CHECK dout0_25 vdout0_25ck111 = 1.8 time = 1120
* CHECK dout0_26 vdout0_26ck111 = 1.8 time = 1120
* CHECK dout0_27 vdout0_27ck111 = 0 time = 1120
* CHECK dout0_28 vdout0_28ck111 = 0 time = 1120
* CHECK dout0_29 vdout0_29ck111 = 0 time = 1120
* CHECK dout0_30 vdout0_30ck111 = 0 time = 1120
* CHECK dout0_31 vdout0_31ck111 = 1.8 time = 1120
* CHECK dout1_0 vdout1_0ck111 = 1.8 time = 1120
* CHECK dout1_1 vdout1_1ck111 = 1.8 time = 1120
* CHECK dout1_2 vdout1_2ck111 = 0 time = 1120
* CHECK dout1_3 vdout1_3ck111 = 1.8 time = 1120
* CHECK dout1_4 vdout1_4ck111 = 0 time = 1120
* CHECK dout1_5 vdout1_5ck111 = 1.8 time = 1120
* CHECK dout1_6 vdout1_6ck111 = 1.8 time = 1120
* CHECK dout1_7 vdout1_7ck111 = 0 time = 1120
* CHECK dout1_8 vdout1_8ck111 = 1.8 time = 1120
* CHECK dout1_9 vdout1_9ck111 = 0 time = 1120
* CHECK dout1_10 vdout1_10ck111 = 1.8 time = 1120
* CHECK dout1_11 vdout1_11ck111 = 1.8 time = 1120
* CHECK dout1_12 vdout1_12ck111 = 1.8 time = 1120
* CHECK dout1_13 vdout1_13ck111 = 1.8 time = 1120
* CHECK dout1_14 vdout1_14ck111 = 0 time = 1120
* CHECK dout1_15 vdout1_15ck111 = 1.8 time = 1120
* CHECK dout1_16 vdout1_16ck111 = 1.8 time = 1120
* CHECK dout1_17 vdout1_17ck111 = 1.8 time = 1120
* CHECK dout1_18 vdout1_18ck111 = 0 time = 1120
* CHECK dout1_19 vdout1_19ck111 = 0 time = 1120
* CHECK dout1_20 vdout1_20ck111 = 1.8 time = 1120
* CHECK dout1_21 vdout1_21ck111 = 0 time = 1120
* CHECK dout1_22 vdout1_22ck111 = 0 time = 1120
* CHECK dout1_23 vdout1_23ck111 = 0 time = 1120
* CHECK dout1_24 vdout1_24ck111 = 0 time = 1120
* CHECK dout1_25 vdout1_25ck111 = 0 time = 1120
* CHECK dout1_26 vdout1_26ck111 = 1.8 time = 1120
* CHECK dout1_27 vdout1_27ck111 = 1.8 time = 1120
* CHECK dout1_28 vdout1_28ck111 = 0 time = 1120
* CHECK dout1_29 vdout1_29ck111 = 1.8 time = 1120
* CHECK dout1_30 vdout1_30ck111 = 0 time = 1120
* CHECK dout1_31 vdout1_31ck111 = 0 time = 1120
* CHECK dout0_0 vdout0_0ck113 = 1.8 time = 1140
* CHECK dout0_1 vdout0_1ck113 = 0 time = 1140
* CHECK dout0_2 vdout0_2ck113 = 0 time = 1140
* CHECK dout0_3 vdout0_3ck113 = 0 time = 1140
* CHECK dout0_4 vdout0_4ck113 = 1.8 time = 1140
* CHECK dout0_5 vdout0_5ck113 = 0 time = 1140
* CHECK dout0_6 vdout0_6ck113 = 0 time = 1140
* CHECK dout0_7 vdout0_7ck113 = 0 time = 1140
* CHECK dout0_8 vdout0_8ck113 = 0 time = 1140
* CHECK dout0_9 vdout0_9ck113 = 0 time = 1140
* CHECK dout0_10 vdout0_10ck113 = 0 time = 1140
* CHECK dout0_11 vdout0_11ck113 = 1.8 time = 1140
* CHECK dout0_12 vdout0_12ck113 = 1.8 time = 1140
* CHECK dout0_13 vdout0_13ck113 = 0 time = 1140
* CHECK dout0_14 vdout0_14ck113 = 0 time = 1140
* CHECK dout0_15 vdout0_15ck113 = 1.8 time = 1140
* CHECK dout0_16 vdout0_16ck113 = 0 time = 1140
* CHECK dout0_17 vdout0_17ck113 = 0 time = 1140
* CHECK dout0_18 vdout0_18ck113 = 0 time = 1140
* CHECK dout0_19 vdout0_19ck113 = 0 time = 1140
* CHECK dout0_20 vdout0_20ck113 = 0 time = 1140
* CHECK dout0_21 vdout0_21ck113 = 1.8 time = 1140
* CHECK dout0_22 vdout0_22ck113 = 0 time = 1140
* CHECK dout0_23 vdout0_23ck113 = 0 time = 1140
* CHECK dout0_24 vdout0_24ck113 = 1.8 time = 1140
* CHECK dout0_25 vdout0_25ck113 = 0 time = 1140
* CHECK dout0_26 vdout0_26ck113 = 1.8 time = 1140
* CHECK dout0_27 vdout0_27ck113 = 0 time = 1140
* CHECK dout0_28 vdout0_28ck113 = 1.8 time = 1140
* CHECK dout0_29 vdout0_29ck113 = 1.8 time = 1140
* CHECK dout0_30 vdout0_30ck113 = 0 time = 1140
* CHECK dout0_31 vdout0_31ck113 = 1.8 time = 1140
* CHECK dout0_0 vdout0_0ck115 = 1.8 time = 1160
* CHECK dout0_1 vdout0_1ck115 = 0 time = 1160
* CHECK dout0_2 vdout0_2ck115 = 0 time = 1160
* CHECK dout0_3 vdout0_3ck115 = 0 time = 1160
* CHECK dout0_4 vdout0_4ck115 = 0 time = 1160
* CHECK dout0_5 vdout0_5ck115 = 0 time = 1160
* CHECK dout0_6 vdout0_6ck115 = 0 time = 1160
* CHECK dout0_7 vdout0_7ck115 = 0 time = 1160
* CHECK dout0_8 vdout0_8ck115 = 0 time = 1160
* CHECK dout0_9 vdout0_9ck115 = 1.8 time = 1160
* CHECK dout0_10 vdout0_10ck115 = 0 time = 1160
* CHECK dout0_11 vdout0_11ck115 = 0 time = 1160
* CHECK dout0_12 vdout0_12ck115 = 1.8 time = 1160
* CHECK dout0_13 vdout0_13ck115 = 1.8 time = 1160
* CHECK dout0_14 vdout0_14ck115 = 0 time = 1160
* CHECK dout0_15 vdout0_15ck115 = 1.8 time = 1160
* CHECK dout0_16 vdout0_16ck115 = 0 time = 1160
* CHECK dout0_17 vdout0_17ck115 = 0 time = 1160
* CHECK dout0_18 vdout0_18ck115 = 0 time = 1160
* CHECK dout0_19 vdout0_19ck115 = 1.8 time = 1160
* CHECK dout0_20 vdout0_20ck115 = 0 time = 1160
* CHECK dout0_21 vdout0_21ck115 = 0 time = 1160
* CHECK dout0_22 vdout0_22ck115 = 0 time = 1160
* CHECK dout0_23 vdout0_23ck115 = 0 time = 1160
* CHECK dout0_24 vdout0_24ck115 = 0 time = 1160
* CHECK dout0_25 vdout0_25ck115 = 1.8 time = 1160
* CHECK dout0_26 vdout0_26ck115 = 1.8 time = 1160
* CHECK dout0_27 vdout0_27ck115 = 0 time = 1160
* CHECK dout0_28 vdout0_28ck115 = 0 time = 1160
* CHECK dout0_29 vdout0_29ck115 = 0 time = 1160
* CHECK dout0_30 vdout0_30ck115 = 0 time = 1160
* CHECK dout0_31 vdout0_31ck115 = 1.8 time = 1160
* CHECK dout1_0 vdout1_0ck117 = 1.8 time = 1180
* CHECK dout1_1 vdout1_1ck117 = 0 time = 1180
* CHECK dout1_2 vdout1_2ck117 = 0 time = 1180
* CHECK dout1_3 vdout1_3ck117 = 1.8 time = 1180
* CHECK dout1_4 vdout1_4ck117 = 0 time = 1180
* CHECK dout1_5 vdout1_5ck117 = 1.8 time = 1180
* CHECK dout1_6 vdout1_6ck117 = 0 time = 1180
* CHECK dout1_7 vdout1_7ck117 = 1.8 time = 1180
* CHECK dout1_8 vdout1_8ck117 = 1.8 time = 1180
* CHECK dout1_9 vdout1_9ck117 = 0 time = 1180
* CHECK dout1_10 vdout1_10ck117 = 0 time = 1180
* CHECK dout1_11 vdout1_11ck117 = 1.8 time = 1180
* CHECK dout1_12 vdout1_12ck117 = 1.8 time = 1180
* CHECK dout1_13 vdout1_13ck117 = 1.8 time = 1180
* CHECK dout1_14 vdout1_14ck117 = 1.8 time = 1180
* CHECK dout1_15 vdout1_15ck117 = 0 time = 1180
* CHECK dout1_16 vdout1_16ck117 = 0 time = 1180
* CHECK dout1_17 vdout1_17ck117 = 0 time = 1180
* CHECK dout1_18 vdout1_18ck117 = 1.8 time = 1180
* CHECK dout1_19 vdout1_19ck117 = 1.8 time = 1180
* CHECK dout1_20 vdout1_20ck117 = 1.8 time = 1180
* CHECK dout1_21 vdout1_21ck117 = 1.8 time = 1180
* CHECK dout1_22 vdout1_22ck117 = 0 time = 1180
* CHECK dout1_23 vdout1_23ck117 = 1.8 time = 1180
* CHECK dout1_24 vdout1_24ck117 = 1.8 time = 1180
* CHECK dout1_25 vdout1_25ck117 = 1.8 time = 1180
* CHECK dout1_26 vdout1_26ck117 = 0 time = 1180
* CHECK dout1_27 vdout1_27ck117 = 1.8 time = 1180
* CHECK dout1_28 vdout1_28ck117 = 0 time = 1180
* CHECK dout1_29 vdout1_29ck117 = 0 time = 1180
* CHECK dout1_30 vdout1_30ck117 = 1.8 time = 1180
* CHECK dout1_31 vdout1_31ck117 = 0 time = 1180
* CHECK dout0_0 vdout0_0ck118 = 1.8 time = 1190
* CHECK dout0_1 vdout0_1ck118 = 0 time = 1190
* CHECK dout0_2 vdout0_2ck118 = 0 time = 1190
* CHECK dout0_3 vdout0_3ck118 = 0 time = 1190
* CHECK dout0_4 vdout0_4ck118 = 1.8 time = 1190
* CHECK dout0_5 vdout0_5ck118 = 0 time = 1190
* CHECK dout0_6 vdout0_6ck118 = 0 time = 1190
* CHECK dout0_7 vdout0_7ck118 = 0 time = 1190
* CHECK dout0_8 vdout0_8ck118 = 0 time = 1190
* CHECK dout0_9 vdout0_9ck118 = 0 time = 1190
* CHECK dout0_10 vdout0_10ck118 = 0 time = 1190
* CHECK dout0_11 vdout0_11ck118 = 1.8 time = 1190
* CHECK dout0_12 vdout0_12ck118 = 1.8 time = 1190
* CHECK dout0_13 vdout0_13ck118 = 0 time = 1190
* CHECK dout0_14 vdout0_14ck118 = 0 time = 1190
* CHECK dout0_15 vdout0_15ck118 = 1.8 time = 1190
* CHECK dout0_16 vdout0_16ck118 = 0 time = 1190
* CHECK dout0_17 vdout0_17ck118 = 0 time = 1190
* CHECK dout0_18 vdout0_18ck118 = 0 time = 1190
* CHECK dout0_19 vdout0_19ck118 = 0 time = 1190
* CHECK dout0_20 vdout0_20ck118 = 0 time = 1190
* CHECK dout0_21 vdout0_21ck118 = 1.8 time = 1190
* CHECK dout0_22 vdout0_22ck118 = 0 time = 1190
* CHECK dout0_23 vdout0_23ck118 = 0 time = 1190
* CHECK dout0_24 vdout0_24ck118 = 1.8 time = 1190
* CHECK dout0_25 vdout0_25ck118 = 0 time = 1190
* CHECK dout0_26 vdout0_26ck118 = 1.8 time = 1190
* CHECK dout0_27 vdout0_27ck118 = 0 time = 1190
* CHECK dout0_28 vdout0_28ck118 = 1.8 time = 1190
* CHECK dout0_29 vdout0_29ck118 = 1.8 time = 1190
* CHECK dout0_30 vdout0_30ck118 = 0 time = 1190
* CHECK dout0_31 vdout0_31ck118 = 1.8 time = 1190
* CHECK dout1_0 vdout1_0ck118 = 1.8 time = 1190
* CHECK dout1_1 vdout1_1ck118 = 0 time = 1190
* CHECK dout1_2 vdout1_2ck118 = 0 time = 1190
* CHECK dout1_3 vdout1_3ck118 = 0 time = 1190
* CHECK dout1_4 vdout1_4ck118 = 1.8 time = 1190
* CHECK dout1_5 vdout1_5ck118 = 0 time = 1190
* CHECK dout1_6 vdout1_6ck118 = 0 time = 1190
* CHECK dout1_7 vdout1_7ck118 = 0 time = 1190
* CHECK dout1_8 vdout1_8ck118 = 0 time = 1190
* CHECK dout1_9 vdout1_9ck118 = 0 time = 1190
* CHECK dout1_10 vdout1_10ck118 = 0 time = 1190
* CHECK dout1_11 vdout1_11ck118 = 1.8 time = 1190
* CHECK dout1_12 vdout1_12ck118 = 1.8 time = 1190
* CHECK dout1_13 vdout1_13ck118 = 0 time = 1190
* CHECK dout1_14 vdout1_14ck118 = 0 time = 1190
* CHECK dout1_15 vdout1_15ck118 = 1.8 time = 1190
* CHECK dout1_16 vdout1_16ck118 = 0 time = 1190
* CHECK dout1_17 vdout1_17ck118 = 0 time = 1190
* CHECK dout1_18 vdout1_18ck118 = 0 time = 1190
* CHECK dout1_19 vdout1_19ck118 = 0 time = 1190
* CHECK dout1_20 vdout1_20ck118 = 0 time = 1190
* CHECK dout1_21 vdout1_21ck118 = 1.8 time = 1190
* CHECK dout1_22 vdout1_22ck118 = 0 time = 1190
* CHECK dout1_23 vdout1_23ck118 = 0 time = 1190
* CHECK dout1_24 vdout1_24ck118 = 1.8 time = 1190
* CHECK dout1_25 vdout1_25ck118 = 0 time = 1190
* CHECK dout1_26 vdout1_26ck118 = 1.8 time = 1190
* CHECK dout1_27 vdout1_27ck118 = 0 time = 1190
* CHECK dout1_28 vdout1_28ck118 = 1.8 time = 1190
* CHECK dout1_29 vdout1_29ck118 = 1.8 time = 1190
* CHECK dout1_30 vdout1_30ck118 = 0 time = 1190
* CHECK dout1_31 vdout1_31ck118 = 1.8 time = 1190
* CHECK dout0_0 vdout0_0ck119 = 1.8 time = 1200
* CHECK dout0_1 vdout0_1ck119 = 0 time = 1200
* CHECK dout0_2 vdout0_2ck119 = 0 time = 1200
* CHECK dout0_3 vdout0_3ck119 = 1.8 time = 1200
* CHECK dout0_4 vdout0_4ck119 = 0 time = 1200
* CHECK dout0_5 vdout0_5ck119 = 1.8 time = 1200
* CHECK dout0_6 vdout0_6ck119 = 0 time = 1200
* CHECK dout0_7 vdout0_7ck119 = 1.8 time = 1200
* CHECK dout0_8 vdout0_8ck119 = 1.8 time = 1200
* CHECK dout0_9 vdout0_9ck119 = 0 time = 1200
* CHECK dout0_10 vdout0_10ck119 = 0 time = 1200
* CHECK dout0_11 vdout0_11ck119 = 1.8 time = 1200
* CHECK dout0_12 vdout0_12ck119 = 1.8 time = 1200
* CHECK dout0_13 vdout0_13ck119 = 1.8 time = 1200
* CHECK dout0_14 vdout0_14ck119 = 1.8 time = 1200
* CHECK dout0_15 vdout0_15ck119 = 0 time = 1200
* CHECK dout0_16 vdout0_16ck119 = 0 time = 1200
* CHECK dout0_17 vdout0_17ck119 = 0 time = 1200
* CHECK dout0_18 vdout0_18ck119 = 1.8 time = 1200
* CHECK dout0_19 vdout0_19ck119 = 1.8 time = 1200
* CHECK dout0_20 vdout0_20ck119 = 1.8 time = 1200
* CHECK dout0_21 vdout0_21ck119 = 1.8 time = 1200
* CHECK dout0_22 vdout0_22ck119 = 0 time = 1200
* CHECK dout0_23 vdout0_23ck119 = 1.8 time = 1200
* CHECK dout0_24 vdout0_24ck119 = 1.8 time = 1200
* CHECK dout0_25 vdout0_25ck119 = 1.8 time = 1200
* CHECK dout0_26 vdout0_26ck119 = 0 time = 1200
* CHECK dout0_27 vdout0_27ck119 = 1.8 time = 1200
* CHECK dout0_28 vdout0_28ck119 = 0 time = 1200
* CHECK dout0_29 vdout0_29ck119 = 0 time = 1200
* CHECK dout0_30 vdout0_30ck119 = 1.8 time = 1200
* CHECK dout0_31 vdout0_31ck119 = 0 time = 1200
* CHECK dout0_0 vdout0_0ck121 = 1.8 time = 1220
* CHECK dout0_1 vdout0_1ck121 = 0 time = 1220
* CHECK dout0_2 vdout0_2ck121 = 0 time = 1220
* CHECK dout0_3 vdout0_3ck121 = 0 time = 1220
* CHECK dout0_4 vdout0_4ck121 = 0 time = 1220
* CHECK dout0_5 vdout0_5ck121 = 0 time = 1220
* CHECK dout0_6 vdout0_6ck121 = 0 time = 1220
* CHECK dout0_7 vdout0_7ck121 = 0 time = 1220
* CHECK dout0_8 vdout0_8ck121 = 0 time = 1220
* CHECK dout0_9 vdout0_9ck121 = 1.8 time = 1220
* CHECK dout0_10 vdout0_10ck121 = 0 time = 1220
* CHECK dout0_11 vdout0_11ck121 = 0 time = 1220
* CHECK dout0_12 vdout0_12ck121 = 1.8 time = 1220
* CHECK dout0_13 vdout0_13ck121 = 1.8 time = 1220
* CHECK dout0_14 vdout0_14ck121 = 0 time = 1220
* CHECK dout0_15 vdout0_15ck121 = 1.8 time = 1220
* CHECK dout0_16 vdout0_16ck121 = 0 time = 1220
* CHECK dout0_17 vdout0_17ck121 = 0 time = 1220
* CHECK dout0_18 vdout0_18ck121 = 0 time = 1220
* CHECK dout0_19 vdout0_19ck121 = 1.8 time = 1220
* CHECK dout0_20 vdout0_20ck121 = 0 time = 1220
* CHECK dout0_21 vdout0_21ck121 = 0 time = 1220
* CHECK dout0_22 vdout0_22ck121 = 0 time = 1220
* CHECK dout0_23 vdout0_23ck121 = 0 time = 1220
* CHECK dout0_24 vdout0_24ck121 = 0 time = 1220
* CHECK dout0_25 vdout0_25ck121 = 1.8 time = 1220
* CHECK dout0_26 vdout0_26ck121 = 1.8 time = 1220
* CHECK dout0_27 vdout0_27ck121 = 0 time = 1220
* CHECK dout0_28 vdout0_28ck121 = 0 time = 1220
* CHECK dout0_29 vdout0_29ck121 = 0 time = 1220
* CHECK dout0_30 vdout0_30ck121 = 0 time = 1220
* CHECK dout0_31 vdout0_31ck121 = 1.8 time = 1220
* CHECK dout1_0 vdout1_0ck121 = 0 time = 1220
* CHECK dout1_1 vdout1_1ck121 = 0 time = 1220
* CHECK dout1_2 vdout1_2ck121 = 0 time = 1220
* CHECK dout1_3 vdout1_3ck121 = 1.8 time = 1220
* CHECK dout1_4 vdout1_4ck121 = 1.8 time = 1220
* CHECK dout1_5 vdout1_5ck121 = 0 time = 1220
* CHECK dout1_6 vdout1_6ck121 = 0 time = 1220
* CHECK dout1_7 vdout1_7ck121 = 0 time = 1220
* CHECK dout1_8 vdout1_8ck121 = 0 time = 1220
* CHECK dout1_9 vdout1_9ck121 = 1.8 time = 1220
* CHECK dout1_10 vdout1_10ck121 = 1.8 time = 1220
* CHECK dout1_11 vdout1_11ck121 = 1.8 time = 1220
* CHECK dout1_12 vdout1_12ck121 = 1.8 time = 1220
* CHECK dout1_13 vdout1_13ck121 = 1.8 time = 1220
* CHECK dout1_14 vdout1_14ck121 = 0 time = 1220
* CHECK dout1_15 vdout1_15ck121 = 0 time = 1220
* CHECK dout1_16 vdout1_16ck121 = 0 time = 1220
* CHECK dout1_17 vdout1_17ck121 = 0 time = 1220
* CHECK dout1_18 vdout1_18ck121 = 0 time = 1220
* CHECK dout1_19 vdout1_19ck121 = 1.8 time = 1220
* CHECK dout1_20 vdout1_20ck121 = 0 time = 1220
* CHECK dout1_21 vdout1_21ck121 = 0 time = 1220
* CHECK dout1_22 vdout1_22ck121 = 0 time = 1220
* CHECK dout1_23 vdout1_23ck121 = 0 time = 1220
* CHECK dout1_24 vdout1_24ck121 = 1.8 time = 1220
* CHECK dout1_25 vdout1_25ck121 = 1.8 time = 1220
* CHECK dout1_26 vdout1_26ck121 = 1.8 time = 1220
* CHECK dout1_27 vdout1_27ck121 = 1.8 time = 1220
* CHECK dout1_28 vdout1_28ck121 = 1.8 time = 1220
* CHECK dout1_29 vdout1_29ck121 = 1.8 time = 1220
* CHECK dout1_30 vdout1_30ck121 = 1.8 time = 1220
* CHECK dout1_31 vdout1_31ck121 = 1.8 time = 1220
* CHECK dout1_0 vdout1_0ck123 = 1.8 time = 1240
* CHECK dout1_1 vdout1_1ck123 = 0 time = 1240
* CHECK dout1_2 vdout1_2ck123 = 0 time = 1240
* CHECK dout1_3 vdout1_3ck123 = 0 time = 1240
* CHECK dout1_4 vdout1_4ck123 = 1.8 time = 1240
* CHECK dout1_5 vdout1_5ck123 = 0 time = 1240
* CHECK dout1_6 vdout1_6ck123 = 0 time = 1240
* CHECK dout1_7 vdout1_7ck123 = 0 time = 1240
* CHECK dout1_8 vdout1_8ck123 = 0 time = 1240
* CHECK dout1_9 vdout1_9ck123 = 0 time = 1240
* CHECK dout1_10 vdout1_10ck123 = 0 time = 1240
* CHECK dout1_11 vdout1_11ck123 = 1.8 time = 1240
* CHECK dout1_12 vdout1_12ck123 = 1.8 time = 1240
* CHECK dout1_13 vdout1_13ck123 = 0 time = 1240
* CHECK dout1_14 vdout1_14ck123 = 0 time = 1240
* CHECK dout1_15 vdout1_15ck123 = 1.8 time = 1240
* CHECK dout1_16 vdout1_16ck123 = 0 time = 1240
* CHECK dout1_17 vdout1_17ck123 = 0 time = 1240
* CHECK dout1_18 vdout1_18ck123 = 0 time = 1240
* CHECK dout1_19 vdout1_19ck123 = 0 time = 1240
* CHECK dout1_20 vdout1_20ck123 = 0 time = 1240
* CHECK dout1_21 vdout1_21ck123 = 1.8 time = 1240
* CHECK dout1_22 vdout1_22ck123 = 0 time = 1240
* CHECK dout1_23 vdout1_23ck123 = 0 time = 1240
* CHECK dout1_24 vdout1_24ck123 = 1.8 time = 1240
* CHECK dout1_25 vdout1_25ck123 = 0 time = 1240
* CHECK dout1_26 vdout1_26ck123 = 1.8 time = 1240
* CHECK dout1_27 vdout1_27ck123 = 0 time = 1240
* CHECK dout1_28 vdout1_28ck123 = 1.8 time = 1240
* CHECK dout1_29 vdout1_29ck123 = 1.8 time = 1240
* CHECK dout1_30 vdout1_30ck123 = 0 time = 1240
* CHECK dout1_31 vdout1_31ck123 = 1.8 time = 1240
* CHECK dout0_0 vdout0_0ck128 = 1.8 time = 1290
* CHECK dout0_1 vdout0_1ck128 = 0 time = 1290
* CHECK dout0_2 vdout0_2ck128 = 0 time = 1290
* CHECK dout0_3 vdout0_3ck128 = 0 time = 1290
* CHECK dout0_4 vdout0_4ck128 = 1.8 time = 1290
* CHECK dout0_5 vdout0_5ck128 = 0 time = 1290
* CHECK dout0_6 vdout0_6ck128 = 0 time = 1290
* CHECK dout0_7 vdout0_7ck128 = 0 time = 1290
* CHECK dout0_8 vdout0_8ck128 = 0 time = 1290
* CHECK dout0_9 vdout0_9ck128 = 0 time = 1290
* CHECK dout0_10 vdout0_10ck128 = 0 time = 1290
* CHECK dout0_11 vdout0_11ck128 = 1.8 time = 1290
* CHECK dout0_12 vdout0_12ck128 = 1.8 time = 1290
* CHECK dout0_13 vdout0_13ck128 = 0 time = 1290
* CHECK dout0_14 vdout0_14ck128 = 0 time = 1290
* CHECK dout0_15 vdout0_15ck128 = 1.8 time = 1290
* CHECK dout0_16 vdout0_16ck128 = 0 time = 1290
* CHECK dout0_17 vdout0_17ck128 = 0 time = 1290
* CHECK dout0_18 vdout0_18ck128 = 0 time = 1290
* CHECK dout0_19 vdout0_19ck128 = 0 time = 1290
* CHECK dout0_20 vdout0_20ck128 = 0 time = 1290
* CHECK dout0_21 vdout0_21ck128 = 1.8 time = 1290
* CHECK dout0_22 vdout0_22ck128 = 0 time = 1290
* CHECK dout0_23 vdout0_23ck128 = 0 time = 1290
* CHECK dout0_24 vdout0_24ck128 = 1.8 time = 1290
* CHECK dout0_25 vdout0_25ck128 = 0 time = 1290
* CHECK dout0_26 vdout0_26ck128 = 1.8 time = 1290
* CHECK dout0_27 vdout0_27ck128 = 1.8 time = 1290
* CHECK dout0_28 vdout0_28ck128 = 1.8 time = 1290
* CHECK dout0_29 vdout0_29ck128 = 1.8 time = 1290
* CHECK dout0_30 vdout0_30ck128 = 1.8 time = 1290
* CHECK dout0_31 vdout0_31ck128 = 1.8 time = 1290
* CHECK dout1_0 vdout1_0ck129 = 1.8 time = 1300
* CHECK dout1_1 vdout1_1ck129 = 0 time = 1300
* CHECK dout1_2 vdout1_2ck129 = 0 time = 1300
* CHECK dout1_3 vdout1_3ck129 = 1.8 time = 1300
* CHECK dout1_4 vdout1_4ck129 = 0 time = 1300
* CHECK dout1_5 vdout1_5ck129 = 1.8 time = 1300
* CHECK dout1_6 vdout1_6ck129 = 0 time = 1300
* CHECK dout1_7 vdout1_7ck129 = 1.8 time = 1300
* CHECK dout1_8 vdout1_8ck129 = 1.8 time = 1300
* CHECK dout1_9 vdout1_9ck129 = 0 time = 1300
* CHECK dout1_10 vdout1_10ck129 = 0 time = 1300
* CHECK dout1_11 vdout1_11ck129 = 1.8 time = 1300
* CHECK dout1_12 vdout1_12ck129 = 1.8 time = 1300
* CHECK dout1_13 vdout1_13ck129 = 1.8 time = 1300
* CHECK dout1_14 vdout1_14ck129 = 1.8 time = 1300
* CHECK dout1_15 vdout1_15ck129 = 0 time = 1300
* CHECK dout1_16 vdout1_16ck129 = 0 time = 1300
* CHECK dout1_17 vdout1_17ck129 = 0 time = 1300
* CHECK dout1_18 vdout1_18ck129 = 1.8 time = 1300
* CHECK dout1_19 vdout1_19ck129 = 1.8 time = 1300
* CHECK dout1_20 vdout1_20ck129 = 1.8 time = 1300
* CHECK dout1_21 vdout1_21ck129 = 1.8 time = 1300
* CHECK dout1_22 vdout1_22ck129 = 0 time = 1300
* CHECK dout1_23 vdout1_23ck129 = 1.8 time = 1300
* CHECK dout1_24 vdout1_24ck129 = 1.8 time = 1300
* CHECK dout1_25 vdout1_25ck129 = 1.8 time = 1300
* CHECK dout1_26 vdout1_26ck129 = 0 time = 1300
* CHECK dout1_27 vdout1_27ck129 = 1.8 time = 1300
* CHECK dout1_28 vdout1_28ck129 = 0 time = 1300
* CHECK dout1_29 vdout1_29ck129 = 0 time = 1300
* CHECK dout1_30 vdout1_30ck129 = 1.8 time = 1300
* CHECK dout1_31 vdout1_31ck129 = 0 time = 1300
* CHECK dout0_0 vdout0_0ck131 = 0 time = 1320
* CHECK dout0_1 vdout0_1ck131 = 0 time = 1320
* CHECK dout0_2 vdout0_2ck131 = 1.8 time = 1320
* CHECK dout0_3 vdout0_3ck131 = 0 time = 1320
* CHECK dout0_4 vdout0_4ck131 = 1.8 time = 1320
* CHECK dout0_5 vdout0_5ck131 = 0 time = 1320
* CHECK dout0_6 vdout0_6ck131 = 1.8 time = 1320
* CHECK dout0_7 vdout0_7ck131 = 1.8 time = 1320
* CHECK dout0_8 vdout0_8ck131 = 0 time = 1320
* CHECK dout0_9 vdout0_9ck131 = 1.8 time = 1320
* CHECK dout0_10 vdout0_10ck131 = 0 time = 1320
* CHECK dout0_11 vdout0_11ck131 = 1.8 time = 1320
* CHECK dout0_12 vdout0_12ck131 = 0 time = 1320
* CHECK dout0_13 vdout0_13ck131 = 1.8 time = 1320
* CHECK dout0_14 vdout0_14ck131 = 1.8 time = 1320
* CHECK dout0_15 vdout0_15ck131 = 0 time = 1320
* CHECK dout0_16 vdout0_16ck131 = 0 time = 1320
* CHECK dout0_17 vdout0_17ck131 = 0 time = 1320
* CHECK dout0_18 vdout0_18ck131 = 1.8 time = 1320
* CHECK dout0_19 vdout0_19ck131 = 1.8 time = 1320
* CHECK dout0_20 vdout0_20ck131 = 1.8 time = 1320
* CHECK dout0_21 vdout0_21ck131 = 0 time = 1320
* CHECK dout0_22 vdout0_22ck131 = 1.8 time = 1320
* CHECK dout0_23 vdout0_23ck131 = 1.8 time = 1320
* CHECK dout0_24 vdout0_24ck131 = 1.8 time = 1320
* CHECK dout0_25 vdout0_25ck131 = 0 time = 1320
* CHECK dout0_26 vdout0_26ck131 = 1.8 time = 1320
* CHECK dout0_27 vdout0_27ck131 = 0 time = 1320
* CHECK dout0_28 vdout0_28ck131 = 0 time = 1320
* CHECK dout0_29 vdout0_29ck131 = 0 time = 1320
* CHECK dout0_30 vdout0_30ck131 = 0 time = 1320
* CHECK dout0_31 vdout0_31ck131 = 0 time = 1320
* CHECK dout1_0 vdout1_0ck131 = 1.8 time = 1320
* CHECK dout1_1 vdout1_1ck131 = 1.8 time = 1320
* CHECK dout1_2 vdout1_2ck131 = 0 time = 1320
* CHECK dout1_3 vdout1_3ck131 = 0 time = 1320
* CHECK dout1_4 vdout1_4ck131 = 0 time = 1320
* CHECK dout1_5 vdout1_5ck131 = 1.8 time = 1320
* CHECK dout1_6 vdout1_6ck131 = 1.8 time = 1320
* CHECK dout1_7 vdout1_7ck131 = 1.8 time = 1320
* CHECK dout1_8 vdout1_8ck131 = 1.8 time = 1320
* CHECK dout1_9 vdout1_9ck131 = 0 time = 1320
* CHECK dout1_10 vdout1_10ck131 = 0 time = 1320
* CHECK dout1_11 vdout1_11ck131 = 1.8 time = 1320
* CHECK dout1_12 vdout1_12ck131 = 1.8 time = 1320
* CHECK dout1_13 vdout1_13ck131 = 1.8 time = 1320
* CHECK dout1_14 vdout1_14ck131 = 0 time = 1320
* CHECK dout1_15 vdout1_15ck131 = 0 time = 1320
* CHECK dout1_16 vdout1_16ck131 = 1.8 time = 1320
* CHECK dout1_17 vdout1_17ck131 = 0 time = 1320
* CHECK dout1_18 vdout1_18ck131 = 1.8 time = 1320
* CHECK dout1_19 vdout1_19ck131 = 1.8 time = 1320
* CHECK dout1_20 vdout1_20ck131 = 0 time = 1320
* CHECK dout1_21 vdout1_21ck131 = 0 time = 1320
* CHECK dout1_22 vdout1_22ck131 = 0 time = 1320
* CHECK dout1_23 vdout1_23ck131 = 1.8 time = 1320
* CHECK dout1_24 vdout1_24ck131 = 0 time = 1320
* CHECK dout1_25 vdout1_25ck131 = 1.8 time = 1320
* CHECK dout1_26 vdout1_26ck131 = 0 time = 1320
* CHECK dout1_27 vdout1_27ck131 = 1.8 time = 1320
* CHECK dout1_28 vdout1_28ck131 = 0 time = 1320
* CHECK dout1_29 vdout1_29ck131 = 0 time = 1320
* CHECK dout1_30 vdout1_30ck131 = 1.8 time = 1320
* CHECK dout1_31 vdout1_31ck131 = 0 time = 1320
* CHECK dout1_0 vdout1_0ck132 = 1.8 time = 1330
* CHECK dout1_1 vdout1_1ck132 = 0 time = 1330
* CHECK dout1_2 vdout1_2ck132 = 0 time = 1330
* CHECK dout1_3 vdout1_3ck132 = 0 time = 1330
* CHECK dout1_4 vdout1_4ck132 = 1.8 time = 1330
* CHECK dout1_5 vdout1_5ck132 = 0 time = 1330
* CHECK dout1_6 vdout1_6ck132 = 0 time = 1330
* CHECK dout1_7 vdout1_7ck132 = 0 time = 1330
* CHECK dout1_8 vdout1_8ck132 = 0 time = 1330
* CHECK dout1_9 vdout1_9ck132 = 0 time = 1330
* CHECK dout1_10 vdout1_10ck132 = 0 time = 1330
* CHECK dout1_11 vdout1_11ck132 = 1.8 time = 1330
* CHECK dout1_12 vdout1_12ck132 = 1.8 time = 1330
* CHECK dout1_13 vdout1_13ck132 = 0 time = 1330
* CHECK dout1_14 vdout1_14ck132 = 0 time = 1330
* CHECK dout1_15 vdout1_15ck132 = 1.8 time = 1330
* CHECK dout1_16 vdout1_16ck132 = 0 time = 1330
* CHECK dout1_17 vdout1_17ck132 = 0 time = 1330
* CHECK dout1_18 vdout1_18ck132 = 0 time = 1330
* CHECK dout1_19 vdout1_19ck132 = 0 time = 1330
* CHECK dout1_20 vdout1_20ck132 = 0 time = 1330
* CHECK dout1_21 vdout1_21ck132 = 1.8 time = 1330
* CHECK dout1_22 vdout1_22ck132 = 0 time = 1330
* CHECK dout1_23 vdout1_23ck132 = 0 time = 1330
* CHECK dout1_24 vdout1_24ck132 = 1.8 time = 1330
* CHECK dout1_25 vdout1_25ck132 = 0 time = 1330
* CHECK dout1_26 vdout1_26ck132 = 1.8 time = 1330
* CHECK dout1_27 vdout1_27ck132 = 1.8 time = 1330
* CHECK dout1_28 vdout1_28ck132 = 1.8 time = 1330
* CHECK dout1_29 vdout1_29ck132 = 1.8 time = 1330
* CHECK dout1_30 vdout1_30ck132 = 1.8 time = 1330
* CHECK dout1_31 vdout1_31ck132 = 1.8 time = 1330
* CHECK dout1_0 vdout1_0ck134 = 1.8 time = 1350
* CHECK dout1_1 vdout1_1ck134 = 0 time = 1350
* CHECK dout1_2 vdout1_2ck134 = 0 time = 1350
* CHECK dout1_3 vdout1_3ck134 = 0 time = 1350
* CHECK dout1_4 vdout1_4ck134 = 0 time = 1350
* CHECK dout1_5 vdout1_5ck134 = 1.8 time = 1350
* CHECK dout1_6 vdout1_6ck134 = 0 time = 1350
* CHECK dout1_7 vdout1_7ck134 = 1.8 time = 1350
* CHECK dout1_8 vdout1_8ck134 = 0 time = 1350
* CHECK dout1_9 vdout1_9ck134 = 1.8 time = 1350
* CHECK dout1_10 vdout1_10ck134 = 0 time = 1350
* CHECK dout1_11 vdout1_11ck134 = 0 time = 1350
* CHECK dout1_12 vdout1_12ck134 = 0 time = 1350
* CHECK dout1_13 vdout1_13ck134 = 0 time = 1350
* CHECK dout1_14 vdout1_14ck134 = 1.8 time = 1350
* CHECK dout1_15 vdout1_15ck134 = 1.8 time = 1350
* CHECK dout1_16 vdout1_16ck134 = 1.8 time = 1350
* CHECK dout1_17 vdout1_17ck134 = 0 time = 1350
* CHECK dout1_18 vdout1_18ck134 = 1.8 time = 1350
* CHECK dout1_19 vdout1_19ck134 = 0 time = 1350
* CHECK dout1_20 vdout1_20ck134 = 0 time = 1350
* CHECK dout1_21 vdout1_21ck134 = 0 time = 1350
* CHECK dout1_22 vdout1_22ck134 = 0 time = 1350
* CHECK dout1_23 vdout1_23ck134 = 0 time = 1350
* CHECK dout1_24 vdout1_24ck134 = 0 time = 1350
* CHECK dout1_25 vdout1_25ck134 = 1.8 time = 1350
* CHECK dout1_26 vdout1_26ck134 = 1.8 time = 1350
* CHECK dout1_27 vdout1_27ck134 = 0 time = 1350
* CHECK dout1_28 vdout1_28ck134 = 1.8 time = 1350
* CHECK dout1_29 vdout1_29ck134 = 0 time = 1350
* CHECK dout1_30 vdout1_30ck134 = 0 time = 1350
* CHECK dout1_31 vdout1_31ck134 = 0 time = 1350
* CHECK dout1_0 vdout1_0ck135 = 1.8 time = 1360
* CHECK dout1_1 vdout1_1ck135 = 1.8 time = 1360
* CHECK dout1_2 vdout1_2ck135 = 0 time = 1360
* CHECK dout1_3 vdout1_3ck135 = 0 time = 1360
* CHECK dout1_4 vdout1_4ck135 = 0 time = 1360
* CHECK dout1_5 vdout1_5ck135 = 0 time = 1360
* CHECK dout1_6 vdout1_6ck135 = 1.8 time = 1360
* CHECK dout1_7 vdout1_7ck135 = 0 time = 1360
* CHECK dout1_8 vdout1_8ck135 = 1.8 time = 1360
* CHECK dout1_9 vdout1_9ck135 = 0 time = 1360
* CHECK dout1_10 vdout1_10ck135 = 0 time = 1360
* CHECK dout1_11 vdout1_11ck135 = 1.8 time = 1360
* CHECK dout1_12 vdout1_12ck135 = 1.8 time = 1360
* CHECK dout1_13 vdout1_13ck135 = 0 time = 1360
* CHECK dout1_14 vdout1_14ck135 = 1.8 time = 1360
* CHECK dout1_15 vdout1_15ck135 = 0 time = 1360
* CHECK dout1_16 vdout1_16ck135 = 0 time = 1360
* CHECK dout1_17 vdout1_17ck135 = 0 time = 1360
* CHECK dout1_18 vdout1_18ck135 = 0 time = 1360
* CHECK dout1_19 vdout1_19ck135 = 1.8 time = 1360
* CHECK dout1_20 vdout1_20ck135 = 0 time = 1360
* CHECK dout1_21 vdout1_21ck135 = 0 time = 1360
* CHECK dout1_22 vdout1_22ck135 = 0 time = 1360
* CHECK dout1_23 vdout1_23ck135 = 0 time = 1360
* CHECK dout1_24 vdout1_24ck135 = 0 time = 1360
* CHECK dout1_25 vdout1_25ck135 = 1.8 time = 1360
* CHECK dout1_26 vdout1_26ck135 = 1.8 time = 1360
* CHECK dout1_27 vdout1_27ck135 = 0 time = 1360
* CHECK dout1_28 vdout1_28ck135 = 0 time = 1360
* CHECK dout1_29 vdout1_29ck135 = 0 time = 1360
* CHECK dout1_30 vdout1_30ck135 = 0 time = 1360
* CHECK dout1_31 vdout1_31ck135 = 1.8 time = 1360
* CHECK dout0_0 vdout0_0ck138 = 1.8 time = 1390
* CHECK dout0_1 vdout0_1ck138 = 0 time = 1390
* CHECK dout0_2 vdout0_2ck138 = 0 time = 1390
* CHECK dout0_3 vdout0_3ck138 = 0 time = 1390
* CHECK dout0_4 vdout0_4ck138 = 1.8 time = 1390
* CHECK dout0_5 vdout0_5ck138 = 0 time = 1390
* CHECK dout0_6 vdout0_6ck138 = 0 time = 1390
* CHECK dout0_7 vdout0_7ck138 = 0 time = 1390
* CHECK dout0_8 vdout0_8ck138 = 0 time = 1390
* CHECK dout0_9 vdout0_9ck138 = 0 time = 1390
* CHECK dout0_10 vdout0_10ck138 = 0 time = 1390
* CHECK dout0_11 vdout0_11ck138 = 1.8 time = 1390
* CHECK dout0_12 vdout0_12ck138 = 1.8 time = 1390
* CHECK dout0_13 vdout0_13ck138 = 0 time = 1390
* CHECK dout0_14 vdout0_14ck138 = 0 time = 1390
* CHECK dout0_15 vdout0_15ck138 = 1.8 time = 1390
* CHECK dout0_16 vdout0_16ck138 = 0 time = 1390
* CHECK dout0_17 vdout0_17ck138 = 0 time = 1390
* CHECK dout0_18 vdout0_18ck138 = 0 time = 1390
* CHECK dout0_19 vdout0_19ck138 = 0 time = 1390
* CHECK dout0_20 vdout0_20ck138 = 0 time = 1390
* CHECK dout0_21 vdout0_21ck138 = 1.8 time = 1390
* CHECK dout0_22 vdout0_22ck138 = 0 time = 1390
* CHECK dout0_23 vdout0_23ck138 = 0 time = 1390
* CHECK dout0_24 vdout0_24ck138 = 1.8 time = 1390
* CHECK dout0_25 vdout0_25ck138 = 0 time = 1390
* CHECK dout0_26 vdout0_26ck138 = 1.8 time = 1390
* CHECK dout0_27 vdout0_27ck138 = 1.8 time = 1390
* CHECK dout0_28 vdout0_28ck138 = 1.8 time = 1390
* CHECK dout0_29 vdout0_29ck138 = 1.8 time = 1390
* CHECK dout0_30 vdout0_30ck138 = 1.8 time = 1390
* CHECK dout0_31 vdout0_31ck138 = 1.8 time = 1390
* CHECK dout1_0 vdout1_0ck138 = 1.8 time = 1390
* CHECK dout1_1 vdout1_1ck138 = 0 time = 1390
* CHECK dout1_2 vdout1_2ck138 = 0 time = 1390
* CHECK dout1_3 vdout1_3ck138 = 0 time = 1390
* CHECK dout1_4 vdout1_4ck138 = 0 time = 1390
* CHECK dout1_5 vdout1_5ck138 = 1.8 time = 1390
* CHECK dout1_6 vdout1_6ck138 = 0 time = 1390
* CHECK dout1_7 vdout1_7ck138 = 1.8 time = 1390
* CHECK dout1_8 vdout1_8ck138 = 0 time = 1390
* CHECK dout1_9 vdout1_9ck138 = 1.8 time = 1390
* CHECK dout1_10 vdout1_10ck138 = 0 time = 1390
* CHECK dout1_11 vdout1_11ck138 = 0 time = 1390
* CHECK dout1_12 vdout1_12ck138 = 0 time = 1390
* CHECK dout1_13 vdout1_13ck138 = 0 time = 1390
* CHECK dout1_14 vdout1_14ck138 = 1.8 time = 1390
* CHECK dout1_15 vdout1_15ck138 = 1.8 time = 1390
* CHECK dout1_16 vdout1_16ck138 = 1.8 time = 1390
* CHECK dout1_17 vdout1_17ck138 = 0 time = 1390
* CHECK dout1_18 vdout1_18ck138 = 1.8 time = 1390
* CHECK dout1_19 vdout1_19ck138 = 0 time = 1390
* CHECK dout1_20 vdout1_20ck138 = 0 time = 1390
* CHECK dout1_21 vdout1_21ck138 = 0 time = 1390
* CHECK dout1_22 vdout1_22ck138 = 0 time = 1390
* CHECK dout1_23 vdout1_23ck138 = 0 time = 1390
* CHECK dout1_24 vdout1_24ck138 = 0 time = 1390
* CHECK dout1_25 vdout1_25ck138 = 1.8 time = 1390
* CHECK dout1_26 vdout1_26ck138 = 1.8 time = 1390
* CHECK dout1_27 vdout1_27ck138 = 0 time = 1390
* CHECK dout1_28 vdout1_28ck138 = 1.8 time = 1390
* CHECK dout1_29 vdout1_29ck138 = 0 time = 1390
* CHECK dout1_30 vdout1_30ck138 = 0 time = 1390
* CHECK dout1_31 vdout1_31ck138 = 0 time = 1390
* CHECK dout0_0 vdout0_0ck139 = 0 time = 1400
* CHECK dout0_1 vdout0_1ck139 = 1.8 time = 1400
* CHECK dout0_2 vdout0_2ck139 = 1.8 time = 1400
* CHECK dout0_3 vdout0_3ck139 = 0 time = 1400
* CHECK dout0_4 vdout0_4ck139 = 0 time = 1400
* CHECK dout0_5 vdout0_5ck139 = 0 time = 1400
* CHECK dout0_6 vdout0_6ck139 = 1.8 time = 1400
* CHECK dout0_7 vdout0_7ck139 = 1.8 time = 1400
* CHECK dout0_8 vdout0_8ck139 = 0 time = 1400
* CHECK dout0_9 vdout0_9ck139 = 1.8 time = 1400
* CHECK dout0_10 vdout0_10ck139 = 0 time = 1400
* CHECK dout0_11 vdout0_11ck139 = 0 time = 1400
* CHECK dout0_12 vdout0_12ck139 = 0 time = 1400
* CHECK dout0_13 vdout0_13ck139 = 1.8 time = 1400
* CHECK dout0_14 vdout0_14ck139 = 1.8 time = 1400
* CHECK dout0_15 vdout0_15ck139 = 1.8 time = 1400
* CHECK dout0_16 vdout0_16ck139 = 0 time = 1400
* CHECK dout0_17 vdout0_17ck139 = 1.8 time = 1400
* CHECK dout0_18 vdout0_18ck139 = 0 time = 1400
* CHECK dout0_19 vdout0_19ck139 = 1.8 time = 1400
* CHECK dout0_20 vdout0_20ck139 = 0 time = 1400
* CHECK dout0_21 vdout0_21ck139 = 1.8 time = 1400
* CHECK dout0_22 vdout0_22ck139 = 0 time = 1400
* CHECK dout0_23 vdout0_23ck139 = 1.8 time = 1400
* CHECK dout0_24 vdout0_24ck139 = 0 time = 1400
* CHECK dout0_25 vdout0_25ck139 = 0 time = 1400
* CHECK dout0_26 vdout0_26ck139 = 0 time = 1400
* CHECK dout0_27 vdout0_27ck139 = 0 time = 1400
* CHECK dout0_28 vdout0_28ck139 = 1.8 time = 1400
* CHECK dout0_29 vdout0_29ck139 = 0 time = 1400
* CHECK dout0_30 vdout0_30ck139 = 1.8 time = 1400
* CHECK dout0_31 vdout0_31ck139 = 1.8 time = 1400
* CHECK dout1_0 vdout1_0ck141 = 1.8 time = 1420
* CHECK dout1_1 vdout1_1ck141 = 0 time = 1420
* CHECK dout1_2 vdout1_2ck141 = 0 time = 1420
* CHECK dout1_3 vdout1_3ck141 = 1.8 time = 1420
* CHECK dout1_4 vdout1_4ck141 = 0 time = 1420
* CHECK dout1_5 vdout1_5ck141 = 1.8 time = 1420
* CHECK dout1_6 vdout1_6ck141 = 1.8 time = 1420
* CHECK dout1_7 vdout1_7ck141 = 0 time = 1420
* CHECK dout1_8 vdout1_8ck141 = 0 time = 1420
* CHECK dout1_9 vdout1_9ck141 = 1.8 time = 1420
* CHECK dout1_10 vdout1_10ck141 = 1.8 time = 1420
* CHECK dout1_11 vdout1_11ck141 = 1.8 time = 1420
* CHECK dout1_12 vdout1_12ck141 = 0 time = 1420
* CHECK dout1_13 vdout1_13ck141 = 0 time = 1420
* CHECK dout1_14 vdout1_14ck141 = 0 time = 1420
* CHECK dout1_15 vdout1_15ck141 = 0 time = 1420
* CHECK dout1_16 vdout1_16ck141 = 0 time = 1420
* CHECK dout1_17 vdout1_17ck141 = 1.8 time = 1420
* CHECK dout1_18 vdout1_18ck141 = 0 time = 1420
* CHECK dout1_19 vdout1_19ck141 = 1.8 time = 1420
* CHECK dout1_20 vdout1_20ck141 = 0 time = 1420
* CHECK dout1_21 vdout1_21ck141 = 0 time = 1420
* CHECK dout1_22 vdout1_22ck141 = 1.8 time = 1420
* CHECK dout1_23 vdout1_23ck141 = 0 time = 1420
* CHECK dout1_24 vdout1_24ck141 = 0 time = 1420
* CHECK dout1_25 vdout1_25ck141 = 1.8 time = 1420
* CHECK dout1_26 vdout1_26ck141 = 0 time = 1420
* CHECK dout1_27 vdout1_27ck141 = 0 time = 1420
* CHECK dout1_28 vdout1_28ck141 = 0 time = 1420
* CHECK dout1_29 vdout1_29ck141 = 0 time = 1420
* CHECK dout1_30 vdout1_30ck141 = 0 time = 1420
* CHECK dout1_31 vdout1_31ck141 = 1.8 time = 1420
* CHECK dout0_0 vdout0_0ck142 = 0 time = 1430
* CHECK dout0_1 vdout0_1ck142 = 1.8 time = 1430
* CHECK dout0_2 vdout0_2ck142 = 1.8 time = 1430
* CHECK dout0_3 vdout0_3ck142 = 0 time = 1430
* CHECK dout0_4 vdout0_4ck142 = 0 time = 1430
* CHECK dout0_5 vdout0_5ck142 = 0 time = 1430
* CHECK dout0_6 vdout0_6ck142 = 1.8 time = 1430
* CHECK dout0_7 vdout0_7ck142 = 1.8 time = 1430
* CHECK dout0_8 vdout0_8ck142 = 0 time = 1430
* CHECK dout0_9 vdout0_9ck142 = 1.8 time = 1430
* CHECK dout0_10 vdout0_10ck142 = 0 time = 1430
* CHECK dout0_11 vdout0_11ck142 = 0 time = 1430
* CHECK dout0_12 vdout0_12ck142 = 0 time = 1430
* CHECK dout0_13 vdout0_13ck142 = 1.8 time = 1430
* CHECK dout0_14 vdout0_14ck142 = 1.8 time = 1430
* CHECK dout0_15 vdout0_15ck142 = 1.8 time = 1430
* CHECK dout0_16 vdout0_16ck142 = 0 time = 1430
* CHECK dout0_17 vdout0_17ck142 = 1.8 time = 1430
* CHECK dout0_18 vdout0_18ck142 = 0 time = 1430
* CHECK dout0_19 vdout0_19ck142 = 1.8 time = 1430
* CHECK dout0_20 vdout0_20ck142 = 0 time = 1430
* CHECK dout0_21 vdout0_21ck142 = 1.8 time = 1430
* CHECK dout0_22 vdout0_22ck142 = 0 time = 1430
* CHECK dout0_23 vdout0_23ck142 = 1.8 time = 1430
* CHECK dout0_24 vdout0_24ck142 = 0 time = 1430
* CHECK dout0_25 vdout0_25ck142 = 0 time = 1430
* CHECK dout0_26 vdout0_26ck142 = 0 time = 1430
* CHECK dout0_27 vdout0_27ck142 = 0 time = 1430
* CHECK dout0_28 vdout0_28ck142 = 1.8 time = 1430
* CHECK dout0_29 vdout0_29ck142 = 0 time = 1430
* CHECK dout0_30 vdout0_30ck142 = 1.8 time = 1430
* CHECK dout0_31 vdout0_31ck142 = 1.8 time = 1430
* CHECK dout1_0 vdout1_0ck142 = 1.8 time = 1430
* CHECK dout1_1 vdout1_1ck142 = 1.8 time = 1430
* CHECK dout1_2 vdout1_2ck142 = 1.8 time = 1430
* CHECK dout1_3 vdout1_3ck142 = 0 time = 1430
* CHECK dout1_4 vdout1_4ck142 = 1.8 time = 1430
* CHECK dout1_5 vdout1_5ck142 = 1.8 time = 1430
* CHECK dout1_6 vdout1_6ck142 = 0 time = 1430
* CHECK dout1_7 vdout1_7ck142 = 1.8 time = 1430
* CHECK dout1_8 vdout1_8ck142 = 1.8 time = 1430
* CHECK dout1_9 vdout1_9ck142 = 0 time = 1430
* CHECK dout1_10 vdout1_10ck142 = 0 time = 1430
* CHECK dout1_11 vdout1_11ck142 = 0 time = 1430
* CHECK dout1_12 vdout1_12ck142 = 1.8 time = 1430
* CHECK dout1_13 vdout1_13ck142 = 0 time = 1430
* CHECK dout1_14 vdout1_14ck142 = 0 time = 1430
* CHECK dout1_15 vdout1_15ck142 = 1.8 time = 1430
* CHECK dout1_16 vdout1_16ck142 = 1.8 time = 1430
* CHECK dout1_17 vdout1_17ck142 = 1.8 time = 1430
* CHECK dout1_18 vdout1_18ck142 = 1.8 time = 1430
* CHECK dout1_19 vdout1_19ck142 = 1.8 time = 1430
* CHECK dout1_20 vdout1_20ck142 = 1.8 time = 1430
* CHECK dout1_21 vdout1_21ck142 = 0 time = 1430
* CHECK dout1_22 vdout1_22ck142 = 0 time = 1430
* CHECK dout1_23 vdout1_23ck142 = 0 time = 1430
* CHECK dout1_24 vdout1_24ck142 = 1.8 time = 1430
* CHECK dout1_25 vdout1_25ck142 = 1.8 time = 1430
* CHECK dout1_26 vdout1_26ck142 = 0 time = 1430
* CHECK dout1_27 vdout1_27ck142 = 0 time = 1430
* CHECK dout1_28 vdout1_28ck142 = 0 time = 1430
* CHECK dout1_29 vdout1_29ck142 = 0 time = 1430
* CHECK dout1_30 vdout1_30ck142 = 1.8 time = 1430
* CHECK dout1_31 vdout1_31ck142 = 1.8 time = 1430
* CHECK dout0_0 vdout0_0ck143 = 0 time = 1440
* CHECK dout0_1 vdout0_1ck143 = 1.8 time = 1440
* CHECK dout0_2 vdout0_2ck143 = 1.8 time = 1440
* CHECK dout0_3 vdout0_3ck143 = 1.8 time = 1440
* CHECK dout0_4 vdout0_4ck143 = 0 time = 1440
* CHECK dout0_5 vdout0_5ck143 = 1.8 time = 1440
* CHECK dout0_6 vdout0_6ck143 = 1.8 time = 1440
* CHECK dout0_7 vdout0_7ck143 = 1.8 time = 1440
* CHECK dout0_8 vdout0_8ck143 = 0 time = 1440
* CHECK dout0_9 vdout0_9ck143 = 0 time = 1440
* CHECK dout0_10 vdout0_10ck143 = 1.8 time = 1440
* CHECK dout0_11 vdout0_11ck143 = 1.8 time = 1440
* CHECK dout0_12 vdout0_12ck143 = 0 time = 1440
* CHECK dout0_13 vdout0_13ck143 = 1.8 time = 1440
* CHECK dout0_14 vdout0_14ck143 = 1.8 time = 1440
* CHECK dout0_15 vdout0_15ck143 = 0 time = 1440
* CHECK dout0_16 vdout0_16ck143 = 1.8 time = 1440
* CHECK dout0_17 vdout0_17ck143 = 0 time = 1440
* CHECK dout0_18 vdout0_18ck143 = 1.8 time = 1440
* CHECK dout0_19 vdout0_19ck143 = 0 time = 1440
* CHECK dout0_20 vdout0_20ck143 = 0 time = 1440
* CHECK dout0_21 vdout0_21ck143 = 1.8 time = 1440
* CHECK dout0_22 vdout0_22ck143 = 1.8 time = 1440
* CHECK dout0_23 vdout0_23ck143 = 0 time = 1440
* CHECK dout0_24 vdout0_24ck143 = 1.8 time = 1440
* CHECK dout0_25 vdout0_25ck143 = 0 time = 1440
* CHECK dout0_26 vdout0_26ck143 = 1.8 time = 1440
* CHECK dout0_27 vdout0_27ck143 = 0 time = 1440
* CHECK dout0_28 vdout0_28ck143 = 1.8 time = 1440
* CHECK dout0_29 vdout0_29ck143 = 0 time = 1440
* CHECK dout0_30 vdout0_30ck143 = 0 time = 1440
* CHECK dout0_31 vdout0_31ck143 = 0 time = 1440
* CHECK dout1_0 vdout1_0ck143 = 1.8 time = 1440
* CHECK dout1_1 vdout1_1ck143 = 0 time = 1440
* CHECK dout1_2 vdout1_2ck143 = 0 time = 1440
* CHECK dout1_3 vdout1_3ck143 = 1.8 time = 1440
* CHECK dout1_4 vdout1_4ck143 = 0 time = 1440
* CHECK dout1_5 vdout1_5ck143 = 1.8 time = 1440
* CHECK dout1_6 vdout1_6ck143 = 0 time = 1440
* CHECK dout1_7 vdout1_7ck143 = 1.8 time = 1440
* CHECK dout1_8 vdout1_8ck143 = 1.8 time = 1440
* CHECK dout1_9 vdout1_9ck143 = 0 time = 1440
* CHECK dout1_10 vdout1_10ck143 = 0 time = 1440
* CHECK dout1_11 vdout1_11ck143 = 1.8 time = 1440
* CHECK dout1_12 vdout1_12ck143 = 1.8 time = 1440
* CHECK dout1_13 vdout1_13ck143 = 1.8 time = 1440
* CHECK dout1_14 vdout1_14ck143 = 1.8 time = 1440
* CHECK dout1_15 vdout1_15ck143 = 0 time = 1440
* CHECK dout1_16 vdout1_16ck143 = 0 time = 1440
* CHECK dout1_17 vdout1_17ck143 = 0 time = 1440
* CHECK dout1_18 vdout1_18ck143 = 1.8 time = 1440
* CHECK dout1_19 vdout1_19ck143 = 1.8 time = 1440
* CHECK dout1_20 vdout1_20ck143 = 1.8 time = 1440
* CHECK dout1_21 vdout1_21ck143 = 1.8 time = 1440
* CHECK dout1_22 vdout1_22ck143 = 0 time = 1440
* CHECK dout1_23 vdout1_23ck143 = 1.8 time = 1440
* CHECK dout1_24 vdout1_24ck143 = 1.8 time = 1440
* CHECK dout1_25 vdout1_25ck143 = 1.8 time = 1440
* CHECK dout1_26 vdout1_26ck143 = 0 time = 1440
* CHECK dout1_27 vdout1_27ck143 = 1.8 time = 1440
* CHECK dout1_28 vdout1_28ck143 = 0 time = 1440
* CHECK dout1_29 vdout1_29ck143 = 0 time = 1440
* CHECK dout1_30 vdout1_30ck143 = 1.8 time = 1440
* CHECK dout1_31 vdout1_31ck143 = 0 time = 1440
* CHECK dout0_0 vdout0_0ck145 = 1.8 time = 1460
* CHECK dout0_1 vdout0_1ck145 = 0 time = 1460
* CHECK dout0_2 vdout0_2ck145 = 0 time = 1460
* CHECK dout0_3 vdout0_3ck145 = 1.8 time = 1460
* CHECK dout0_4 vdout0_4ck145 = 0 time = 1460
* CHECK dout0_5 vdout0_5ck145 = 1.8 time = 1460
* CHECK dout0_6 vdout0_6ck145 = 1.8 time = 1460
* CHECK dout0_7 vdout0_7ck145 = 0 time = 1460
* CHECK dout0_8 vdout0_8ck145 = 0 time = 1460
* CHECK dout0_9 vdout0_9ck145 = 1.8 time = 1460
* CHECK dout0_10 vdout0_10ck145 = 1.8 time = 1460
* CHECK dout0_11 vdout0_11ck145 = 1.8 time = 1460
* CHECK dout0_12 vdout0_12ck145 = 0 time = 1460
* CHECK dout0_13 vdout0_13ck145 = 0 time = 1460
* CHECK dout0_14 vdout0_14ck145 = 0 time = 1460
* CHECK dout0_15 vdout0_15ck145 = 0 time = 1460
* CHECK dout0_16 vdout0_16ck145 = 0 time = 1460
* CHECK dout0_17 vdout0_17ck145 = 1.8 time = 1460
* CHECK dout0_18 vdout0_18ck145 = 0 time = 1460
* CHECK dout0_19 vdout0_19ck145 = 1.8 time = 1460
* CHECK dout0_20 vdout0_20ck145 = 0 time = 1460
* CHECK dout0_21 vdout0_21ck145 = 0 time = 1460
* CHECK dout0_22 vdout0_22ck145 = 1.8 time = 1460
* CHECK dout0_23 vdout0_23ck145 = 0 time = 1460
* CHECK dout0_24 vdout0_24ck145 = 0 time = 1460
* CHECK dout0_25 vdout0_25ck145 = 1.8 time = 1460
* CHECK dout0_26 vdout0_26ck145 = 0 time = 1460
* CHECK dout0_27 vdout0_27ck145 = 0 time = 1460
* CHECK dout0_28 vdout0_28ck145 = 0 time = 1460
* CHECK dout0_29 vdout0_29ck145 = 0 time = 1460
* CHECK dout0_30 vdout0_30ck145 = 0 time = 1460
* CHECK dout0_31 vdout0_31ck145 = 1.8 time = 1460
* CHECK dout1_0 vdout1_0ck145 = 0 time = 1460
* CHECK dout1_1 vdout1_1ck145 = 1.8 time = 1460
* CHECK dout1_2 vdout1_2ck145 = 1.8 time = 1460
* CHECK dout1_3 vdout1_3ck145 = 1.8 time = 1460
* CHECK dout1_4 vdout1_4ck145 = 0 time = 1460
* CHECK dout1_5 vdout1_5ck145 = 1.8 time = 1460
* CHECK dout1_6 vdout1_6ck145 = 1.8 time = 1460
* CHECK dout1_7 vdout1_7ck145 = 1.8 time = 1460
* CHECK dout1_8 vdout1_8ck145 = 0 time = 1460
* CHECK dout1_9 vdout1_9ck145 = 0 time = 1460
* CHECK dout1_10 vdout1_10ck145 = 1.8 time = 1460
* CHECK dout1_11 vdout1_11ck145 = 1.8 time = 1460
* CHECK dout1_12 vdout1_12ck145 = 0 time = 1460
* CHECK dout1_13 vdout1_13ck145 = 1.8 time = 1460
* CHECK dout1_14 vdout1_14ck145 = 1.8 time = 1460
* CHECK dout1_15 vdout1_15ck145 = 0 time = 1460
* CHECK dout1_16 vdout1_16ck145 = 1.8 time = 1460
* CHECK dout1_17 vdout1_17ck145 = 0 time = 1460
* CHECK dout1_18 vdout1_18ck145 = 1.8 time = 1460
* CHECK dout1_19 vdout1_19ck145 = 0 time = 1460
* CHECK dout1_20 vdout1_20ck145 = 0 time = 1460
* CHECK dout1_21 vdout1_21ck145 = 1.8 time = 1460
* CHECK dout1_22 vdout1_22ck145 = 1.8 time = 1460
* CHECK dout1_23 vdout1_23ck145 = 0 time = 1460
* CHECK dout1_24 vdout1_24ck145 = 1.8 time = 1460
* CHECK dout1_25 vdout1_25ck145 = 0 time = 1460
* CHECK dout1_26 vdout1_26ck145 = 1.8 time = 1460
* CHECK dout1_27 vdout1_27ck145 = 0 time = 1460
* CHECK dout1_28 vdout1_28ck145 = 1.8 time = 1460
* CHECK dout1_29 vdout1_29ck145 = 0 time = 1460
* CHECK dout1_30 vdout1_30ck145 = 0 time = 1460
* CHECK dout1_31 vdout1_31ck145 = 0 time = 1460
* CHECK dout0_0 vdout0_0ck148 = 0 time = 1490
* CHECK dout0_1 vdout0_1ck148 = 0 time = 1490
* CHECK dout0_2 vdout0_2ck148 = 1.8 time = 1490
* CHECK dout0_3 vdout0_3ck148 = 0 time = 1490
* CHECK dout0_4 vdout0_4ck148 = 0 time = 1490
* CHECK dout0_5 vdout0_5ck148 = 0 time = 1490
* CHECK dout0_6 vdout0_6ck148 = 1.8 time = 1490
* CHECK dout0_7 vdout0_7ck148 = 1.8 time = 1490
* CHECK dout0_8 vdout0_8ck148 = 1.8 time = 1490
* CHECK dout0_9 vdout0_9ck148 = 1.8 time = 1490
* CHECK dout0_10 vdout0_10ck148 = 0 time = 1490
* CHECK dout0_11 vdout0_11ck148 = 0 time = 1490
* CHECK dout0_12 vdout0_12ck148 = 1.8 time = 1490
* CHECK dout0_13 vdout0_13ck148 = 0 time = 1490
* CHECK dout0_14 vdout0_14ck148 = 0 time = 1490
* CHECK dout0_15 vdout0_15ck148 = 0 time = 1490
* CHECK dout0_16 vdout0_16ck148 = 0 time = 1490
* CHECK dout0_17 vdout0_17ck148 = 1.8 time = 1490
* CHECK dout0_18 vdout0_18ck148 = 0 time = 1490
* CHECK dout0_19 vdout0_19ck148 = 1.8 time = 1490
* CHECK dout0_20 vdout0_20ck148 = 1.8 time = 1490
* CHECK dout0_21 vdout0_21ck148 = 0 time = 1490
* CHECK dout0_22 vdout0_22ck148 = 1.8 time = 1490
* CHECK dout0_23 vdout0_23ck148 = 0 time = 1490
* CHECK dout0_24 vdout0_24ck148 = 0 time = 1490
* CHECK dout0_25 vdout0_25ck148 = 1.8 time = 1490
* CHECK dout0_26 vdout0_26ck148 = 0 time = 1490
* CHECK dout0_27 vdout0_27ck148 = 1.8 time = 1490
* CHECK dout0_28 vdout0_28ck148 = 0 time = 1490
* CHECK dout0_29 vdout0_29ck148 = 0 time = 1490
* CHECK dout0_30 vdout0_30ck148 = 0 time = 1490
* CHECK dout0_31 vdout0_31ck148 = 1.8 time = 1490
* CHECK dout1_0 vdout1_0ck148 = 0 time = 1490
* CHECK dout1_1 vdout1_1ck148 = 1.8 time = 1490
* CHECK dout1_2 vdout1_2ck148 = 1.8 time = 1490
* CHECK dout1_3 vdout1_3ck148 = 1.8 time = 1490
* CHECK dout1_4 vdout1_4ck148 = 0 time = 1490
* CHECK dout1_5 vdout1_5ck148 = 1.8 time = 1490
* CHECK dout1_6 vdout1_6ck148 = 1.8 time = 1490
* CHECK dout1_7 vdout1_7ck148 = 1.8 time = 1490
* CHECK dout1_8 vdout1_8ck148 = 0 time = 1490
* CHECK dout1_9 vdout1_9ck148 = 0 time = 1490
* CHECK dout1_10 vdout1_10ck148 = 1.8 time = 1490
* CHECK dout1_11 vdout1_11ck148 = 1.8 time = 1490
* CHECK dout1_12 vdout1_12ck148 = 0 time = 1490
* CHECK dout1_13 vdout1_13ck148 = 1.8 time = 1490
* CHECK dout1_14 vdout1_14ck148 = 1.8 time = 1490
* CHECK dout1_15 vdout1_15ck148 = 0 time = 1490
* CHECK dout1_16 vdout1_16ck148 = 1.8 time = 1490
* CHECK dout1_17 vdout1_17ck148 = 0 time = 1490
* CHECK dout1_18 vdout1_18ck148 = 1.8 time = 1490
* CHECK dout1_19 vdout1_19ck148 = 0 time = 1490
* CHECK dout1_20 vdout1_20ck148 = 0 time = 1490
* CHECK dout1_21 vdout1_21ck148 = 1.8 time = 1490
* CHECK dout1_22 vdout1_22ck148 = 1.8 time = 1490
* CHECK dout1_23 vdout1_23ck148 = 0 time = 1490
* CHECK dout1_24 vdout1_24ck148 = 1.8 time = 1490
* CHECK dout1_25 vdout1_25ck148 = 0 time = 1490
* CHECK dout1_26 vdout1_26ck148 = 1.8 time = 1490
* CHECK dout1_27 vdout1_27ck148 = 0 time = 1490
* CHECK dout1_28 vdout1_28ck148 = 1.8 time = 1490
* CHECK dout1_29 vdout1_29ck148 = 0 time = 1490
* CHECK dout1_30 vdout1_30ck148 = 0 time = 1490
* CHECK dout1_31 vdout1_31ck148 = 0 time = 1490
* CHECK dout0_0 vdout0_0ck149 = 1.8 time = 1500
* CHECK dout0_1 vdout0_1ck149 = 0 time = 1500
* CHECK dout0_2 vdout0_2ck149 = 0 time = 1500
* CHECK dout0_3 vdout0_3ck149 = 1.8 time = 1500
* CHECK dout0_4 vdout0_4ck149 = 0 time = 1500
* CHECK dout0_5 vdout0_5ck149 = 1.8 time = 1500
* CHECK dout0_6 vdout0_6ck149 = 1.8 time = 1500
* CHECK dout0_7 vdout0_7ck149 = 0 time = 1500
* CHECK dout0_8 vdout0_8ck149 = 0 time = 1500
* CHECK dout0_9 vdout0_9ck149 = 1.8 time = 1500
* CHECK dout0_10 vdout0_10ck149 = 1.8 time = 1500
* CHECK dout0_11 vdout0_11ck149 = 1.8 time = 1500
* CHECK dout0_12 vdout0_12ck149 = 0 time = 1500
* CHECK dout0_13 vdout0_13ck149 = 0 time = 1500
* CHECK dout0_14 vdout0_14ck149 = 0 time = 1500
* CHECK dout0_15 vdout0_15ck149 = 0 time = 1500
* CHECK dout0_16 vdout0_16ck149 = 0 time = 1500
* CHECK dout0_17 vdout0_17ck149 = 1.8 time = 1500
* CHECK dout0_18 vdout0_18ck149 = 0 time = 1500
* CHECK dout0_19 vdout0_19ck149 = 1.8 time = 1500
* CHECK dout0_20 vdout0_20ck149 = 0 time = 1500
* CHECK dout0_21 vdout0_21ck149 = 0 time = 1500
* CHECK dout0_22 vdout0_22ck149 = 1.8 time = 1500
* CHECK dout0_23 vdout0_23ck149 = 0 time = 1500
* CHECK dout0_24 vdout0_24ck149 = 0 time = 1500
* CHECK dout0_25 vdout0_25ck149 = 1.8 time = 1500
* CHECK dout0_26 vdout0_26ck149 = 0 time = 1500
* CHECK dout0_27 vdout0_27ck149 = 0 time = 1500
* CHECK dout0_28 vdout0_28ck149 = 0 time = 1500
* CHECK dout0_29 vdout0_29ck149 = 0 time = 1500
* CHECK dout0_30 vdout0_30ck149 = 0 time = 1500
* CHECK dout0_31 vdout0_31ck149 = 1.8 time = 1500
* CHECK dout1_0 vdout1_0ck149 = 0 time = 1500
* CHECK dout1_1 vdout1_1ck149 = 0 time = 1500
* CHECK dout1_2 vdout1_2ck149 = 1.8 time = 1500
* CHECK dout1_3 vdout1_3ck149 = 0 time = 1500
* CHECK dout1_4 vdout1_4ck149 = 0 time = 1500
* CHECK dout1_5 vdout1_5ck149 = 0 time = 1500
* CHECK dout1_6 vdout1_6ck149 = 1.8 time = 1500
* CHECK dout1_7 vdout1_7ck149 = 1.8 time = 1500
* CHECK dout1_8 vdout1_8ck149 = 1.8 time = 1500
* CHECK dout1_9 vdout1_9ck149 = 1.8 time = 1500
* CHECK dout1_10 vdout1_10ck149 = 0 time = 1500
* CHECK dout1_11 vdout1_11ck149 = 0 time = 1500
* CHECK dout1_12 vdout1_12ck149 = 1.8 time = 1500
* CHECK dout1_13 vdout1_13ck149 = 0 time = 1500
* CHECK dout1_14 vdout1_14ck149 = 0 time = 1500
* CHECK dout1_15 vdout1_15ck149 = 0 time = 1500
* CHECK dout1_16 vdout1_16ck149 = 0 time = 1500
* CHECK dout1_17 vdout1_17ck149 = 1.8 time = 1500
* CHECK dout1_18 vdout1_18ck149 = 0 time = 1500
* CHECK dout1_19 vdout1_19ck149 = 1.8 time = 1500
* CHECK dout1_20 vdout1_20ck149 = 1.8 time = 1500
* CHECK dout1_21 vdout1_21ck149 = 0 time = 1500
* CHECK dout1_22 vdout1_22ck149 = 1.8 time = 1500
* CHECK dout1_23 vdout1_23ck149 = 0 time = 1500
* CHECK dout1_24 vdout1_24ck149 = 0 time = 1500
* CHECK dout1_25 vdout1_25ck149 = 1.8 time = 1500
* CHECK dout1_26 vdout1_26ck149 = 0 time = 1500
* CHECK dout1_27 vdout1_27ck149 = 1.8 time = 1500
* CHECK dout1_28 vdout1_28ck149 = 0 time = 1500
* CHECK dout1_29 vdout1_29ck149 = 0 time = 1500
* CHECK dout1_30 vdout1_30ck149 = 0 time = 1500
* CHECK dout1_31 vdout1_31ck149 = 1.8 time = 1500
* CHECK dout1_0 vdout1_0ck150 = 0 time = 1510
* CHECK dout1_1 vdout1_1ck150 = 1.8 time = 1510
* CHECK dout1_2 vdout1_2ck150 = 1.8 time = 1510
* CHECK dout1_3 vdout1_3ck150 = 1.8 time = 1510
* CHECK dout1_4 vdout1_4ck150 = 0 time = 1510
* CHECK dout1_5 vdout1_5ck150 = 1.8 time = 1510
* CHECK dout1_6 vdout1_6ck150 = 1.8 time = 1510
* CHECK dout1_7 vdout1_7ck150 = 1.8 time = 1510
* CHECK dout1_8 vdout1_8ck150 = 0 time = 1510
* CHECK dout1_9 vdout1_9ck150 = 0 time = 1510
* CHECK dout1_10 vdout1_10ck150 = 1.8 time = 1510
* CHECK dout1_11 vdout1_11ck150 = 1.8 time = 1510
* CHECK dout1_12 vdout1_12ck150 = 0 time = 1510
* CHECK dout1_13 vdout1_13ck150 = 1.8 time = 1510
* CHECK dout1_14 vdout1_14ck150 = 1.8 time = 1510
* CHECK dout1_15 vdout1_15ck150 = 0 time = 1510
* CHECK dout1_16 vdout1_16ck150 = 1.8 time = 1510
* CHECK dout1_17 vdout1_17ck150 = 0 time = 1510
* CHECK dout1_18 vdout1_18ck150 = 1.8 time = 1510
* CHECK dout1_19 vdout1_19ck150 = 0 time = 1510
* CHECK dout1_20 vdout1_20ck150 = 0 time = 1510
* CHECK dout1_21 vdout1_21ck150 = 1.8 time = 1510
* CHECK dout1_22 vdout1_22ck150 = 1.8 time = 1510
* CHECK dout1_23 vdout1_23ck150 = 0 time = 1510
* CHECK dout1_24 vdout1_24ck150 = 1.8 time = 1510
* CHECK dout1_25 vdout1_25ck150 = 0 time = 1510
* CHECK dout1_26 vdout1_26ck150 = 1.8 time = 1510
* CHECK dout1_27 vdout1_27ck150 = 0 time = 1510
* CHECK dout1_28 vdout1_28ck150 = 1.8 time = 1510
* CHECK dout1_29 vdout1_29ck150 = 0 time = 1510
* CHECK dout1_30 vdout1_30ck150 = 0 time = 1510
* CHECK dout1_31 vdout1_31ck150 = 0 time = 1510
* CHECK dout0_0 vdout0_0ck151 = 1.8 time = 1520
* CHECK dout0_1 vdout0_1ck151 = 1.8 time = 1520
* CHECK dout0_2 vdout0_2ck151 = 1.8 time = 1520
* CHECK dout0_3 vdout0_3ck151 = 0 time = 1520
* CHECK dout0_4 vdout0_4ck151 = 1.8 time = 1520
* CHECK dout0_5 vdout0_5ck151 = 1.8 time = 1520
* CHECK dout0_6 vdout0_6ck151 = 0 time = 1520
* CHECK dout0_7 vdout0_7ck151 = 1.8 time = 1520
* CHECK dout0_8 vdout0_8ck151 = 1.8 time = 1520
* CHECK dout0_9 vdout0_9ck151 = 0 time = 1520
* CHECK dout0_10 vdout0_10ck151 = 0 time = 1520
* CHECK dout0_11 vdout0_11ck151 = 0 time = 1520
* CHECK dout0_12 vdout0_12ck151 = 1.8 time = 1520
* CHECK dout0_13 vdout0_13ck151 = 0 time = 1520
* CHECK dout0_14 vdout0_14ck151 = 0 time = 1520
* CHECK dout0_15 vdout0_15ck151 = 1.8 time = 1520
* CHECK dout0_16 vdout0_16ck151 = 1.8 time = 1520
* CHECK dout0_17 vdout0_17ck151 = 1.8 time = 1520
* CHECK dout0_18 vdout0_18ck151 = 1.8 time = 1520
* CHECK dout0_19 vdout0_19ck151 = 1.8 time = 1520
* CHECK dout0_20 vdout0_20ck151 = 1.8 time = 1520
* CHECK dout0_21 vdout0_21ck151 = 0 time = 1520
* CHECK dout0_22 vdout0_22ck151 = 0 time = 1520
* CHECK dout0_23 vdout0_23ck151 = 0 time = 1520
* CHECK dout0_24 vdout0_24ck151 = 1.8 time = 1520
* CHECK dout0_25 vdout0_25ck151 = 1.8 time = 1520
* CHECK dout0_26 vdout0_26ck151 = 0 time = 1520
* CHECK dout0_27 vdout0_27ck151 = 0 time = 1520
* CHECK dout0_28 vdout0_28ck151 = 0 time = 1520
* CHECK dout0_29 vdout0_29ck151 = 0 time = 1520
* CHECK dout0_30 vdout0_30ck151 = 1.8 time = 1520
* CHECK dout0_31 vdout0_31ck151 = 1.8 time = 1520
* CHECK dout0_0 vdout0_0ck152 = 0 time = 1530
* CHECK dout0_1 vdout0_1ck152 = 1.8 time = 1530
* CHECK dout0_2 vdout0_2ck152 = 0 time = 1530
* CHECK dout0_3 vdout0_3ck152 = 0 time = 1530
* CHECK dout0_4 vdout0_4ck152 = 0 time = 1530
* CHECK dout0_5 vdout0_5ck152 = 0 time = 1530
* CHECK dout0_6 vdout0_6ck152 = 0 time = 1530
* CHECK dout0_7 vdout0_7ck152 = 0 time = 1530
* CHECK dout0_8 vdout0_8ck152 = 0 time = 1530
* CHECK dout0_9 vdout0_9ck152 = 1.8 time = 1530
* CHECK dout0_10 vdout0_10ck152 = 0 time = 1530
* CHECK dout0_11 vdout0_11ck152 = 0 time = 1530
* CHECK dout0_12 vdout0_12ck152 = 0 time = 1530
* CHECK dout0_13 vdout0_13ck152 = 1.8 time = 1530
* CHECK dout0_14 vdout0_14ck152 = 1.8 time = 1530
* CHECK dout0_15 vdout0_15ck152 = 1.8 time = 1530
* CHECK dout0_16 vdout0_16ck152 = 0 time = 1530
* CHECK dout0_17 vdout0_17ck152 = 0 time = 1530
* CHECK dout0_18 vdout0_18ck152 = 1.8 time = 1530
* CHECK dout0_19 vdout0_19ck152 = 1.8 time = 1530
* CHECK dout0_20 vdout0_20ck152 = 0 time = 1530
* CHECK dout0_21 vdout0_21ck152 = 1.8 time = 1530
* CHECK dout0_22 vdout0_22ck152 = 0 time = 1530
* CHECK dout0_23 vdout0_23ck152 = 0 time = 1530
* CHECK dout0_24 vdout0_24ck152 = 0 time = 1530
* CHECK dout0_25 vdout0_25ck152 = 0 time = 1530
* CHECK dout0_26 vdout0_26ck152 = 0 time = 1530
* CHECK dout0_27 vdout0_27ck152 = 0 time = 1530
* CHECK dout0_28 vdout0_28ck152 = 1.8 time = 1530
* CHECK dout0_29 vdout0_29ck152 = 0 time = 1530
* CHECK dout0_30 vdout0_30ck152 = 1.8 time = 1530
* CHECK dout0_31 vdout0_31ck152 = 1.8 time = 1530
* CHECK dout1_0 vdout1_0ck152 = 0 time = 1530
* CHECK dout1_1 vdout1_1ck152 = 1.8 time = 1530
* CHECK dout1_2 vdout1_2ck152 = 1.8 time = 1530
* CHECK dout1_3 vdout1_3ck152 = 1.8 time = 1530
* CHECK dout1_4 vdout1_4ck152 = 0 time = 1530
* CHECK dout1_5 vdout1_5ck152 = 1.8 time = 1530
* CHECK dout1_6 vdout1_6ck152 = 1.8 time = 1530
* CHECK dout1_7 vdout1_7ck152 = 1.8 time = 1530
* CHECK dout1_8 vdout1_8ck152 = 0 time = 1530
* CHECK dout1_9 vdout1_9ck152 = 0 time = 1530
* CHECK dout1_10 vdout1_10ck152 = 1.8 time = 1530
* CHECK dout1_11 vdout1_11ck152 = 1.8 time = 1530
* CHECK dout1_12 vdout1_12ck152 = 0 time = 1530
* CHECK dout1_13 vdout1_13ck152 = 1.8 time = 1530
* CHECK dout1_14 vdout1_14ck152 = 1.8 time = 1530
* CHECK dout1_15 vdout1_15ck152 = 0 time = 1530
* CHECK dout1_16 vdout1_16ck152 = 1.8 time = 1530
* CHECK dout1_17 vdout1_17ck152 = 0 time = 1530
* CHECK dout1_18 vdout1_18ck152 = 1.8 time = 1530
* CHECK dout1_19 vdout1_19ck152 = 0 time = 1530
* CHECK dout1_20 vdout1_20ck152 = 0 time = 1530
* CHECK dout1_21 vdout1_21ck152 = 1.8 time = 1530
* CHECK dout1_22 vdout1_22ck152 = 1.8 time = 1530
* CHECK dout1_23 vdout1_23ck152 = 0 time = 1530
* CHECK dout1_24 vdout1_24ck152 = 1.8 time = 1530
* CHECK dout1_25 vdout1_25ck152 = 0 time = 1530
* CHECK dout1_26 vdout1_26ck152 = 1.8 time = 1530
* CHECK dout1_27 vdout1_27ck152 = 0 time = 1530
* CHECK dout1_28 vdout1_28ck152 = 1.8 time = 1530
* CHECK dout1_29 vdout1_29ck152 = 0 time = 1530
* CHECK dout1_30 vdout1_30ck152 = 0 time = 1530
* CHECK dout1_31 vdout1_31ck152 = 0 time = 1530
* CHECK dout0_0 vdout0_0ck153 = 0 time = 1540
* CHECK dout0_1 vdout0_1ck153 = 1.8 time = 1540
* CHECK dout0_2 vdout0_2ck153 = 1.8 time = 1540
* CHECK dout0_3 vdout0_3ck153 = 1.8 time = 1540
* CHECK dout0_4 vdout0_4ck153 = 0 time = 1540
* CHECK dout0_5 vdout0_5ck153 = 1.8 time = 1540
* CHECK dout0_6 vdout0_6ck153 = 1.8 time = 1540
* CHECK dout0_7 vdout0_7ck153 = 1.8 time = 1540
* CHECK dout0_8 vdout0_8ck153 = 0 time = 1540
* CHECK dout0_9 vdout0_9ck153 = 0 time = 1540
* CHECK dout0_10 vdout0_10ck153 = 1.8 time = 1540
* CHECK dout0_11 vdout0_11ck153 = 1.8 time = 1540
* CHECK dout0_12 vdout0_12ck153 = 0 time = 1540
* CHECK dout0_13 vdout0_13ck153 = 1.8 time = 1540
* CHECK dout0_14 vdout0_14ck153 = 1.8 time = 1540
* CHECK dout0_15 vdout0_15ck153 = 0 time = 1540
* CHECK dout0_16 vdout0_16ck153 = 1.8 time = 1540
* CHECK dout0_17 vdout0_17ck153 = 0 time = 1540
* CHECK dout0_18 vdout0_18ck153 = 1.8 time = 1540
* CHECK dout0_19 vdout0_19ck153 = 0 time = 1540
* CHECK dout0_20 vdout0_20ck153 = 0 time = 1540
* CHECK dout0_21 vdout0_21ck153 = 1.8 time = 1540
* CHECK dout0_22 vdout0_22ck153 = 1.8 time = 1540
* CHECK dout0_23 vdout0_23ck153 = 0 time = 1540
* CHECK dout0_24 vdout0_24ck153 = 1.8 time = 1540
* CHECK dout0_25 vdout0_25ck153 = 0 time = 1540
* CHECK dout0_26 vdout0_26ck153 = 1.8 time = 1540
* CHECK dout0_27 vdout0_27ck153 = 0 time = 1540
* CHECK dout0_28 vdout0_28ck153 = 1.8 time = 1540
* CHECK dout0_29 vdout0_29ck153 = 0 time = 1540
* CHECK dout0_30 vdout0_30ck153 = 0 time = 1540
* CHECK dout0_31 vdout0_31ck153 = 0 time = 1540
* CHECK dout0_0 vdout0_0ck154 = 0 time = 1550
* CHECK dout0_1 vdout0_1ck154 = 1.8 time = 1550
* CHECK dout0_2 vdout0_2ck154 = 1.8 time = 1550
* CHECK dout0_3 vdout0_3ck154 = 1.8 time = 1550
* CHECK dout0_4 vdout0_4ck154 = 0 time = 1550
* CHECK dout0_5 vdout0_5ck154 = 1.8 time = 1550
* CHECK dout0_6 vdout0_6ck154 = 1.8 time = 1550
* CHECK dout0_7 vdout0_7ck154 = 1.8 time = 1550
* CHECK dout0_8 vdout0_8ck154 = 0 time = 1550
* CHECK dout0_9 vdout0_9ck154 = 0 time = 1550
* CHECK dout0_10 vdout0_10ck154 = 1.8 time = 1550
* CHECK dout0_11 vdout0_11ck154 = 1.8 time = 1550
* CHECK dout0_12 vdout0_12ck154 = 0 time = 1550
* CHECK dout0_13 vdout0_13ck154 = 1.8 time = 1550
* CHECK dout0_14 vdout0_14ck154 = 1.8 time = 1550
* CHECK dout0_15 vdout0_15ck154 = 0 time = 1550
* CHECK dout0_16 vdout0_16ck154 = 1.8 time = 1550
* CHECK dout0_17 vdout0_17ck154 = 0 time = 1550
* CHECK dout0_18 vdout0_18ck154 = 1.8 time = 1550
* CHECK dout0_19 vdout0_19ck154 = 0 time = 1550
* CHECK dout0_20 vdout0_20ck154 = 0 time = 1550
* CHECK dout0_21 vdout0_21ck154 = 1.8 time = 1550
* CHECK dout0_22 vdout0_22ck154 = 1.8 time = 1550
* CHECK dout0_23 vdout0_23ck154 = 0 time = 1550
* CHECK dout0_24 vdout0_24ck154 = 1.8 time = 1550
* CHECK dout0_25 vdout0_25ck154 = 0 time = 1550
* CHECK dout0_26 vdout0_26ck154 = 1.8 time = 1550
* CHECK dout0_27 vdout0_27ck154 = 0 time = 1550
* CHECK dout0_28 vdout0_28ck154 = 1.8 time = 1550
* CHECK dout0_29 vdout0_29ck154 = 0 time = 1550
* CHECK dout0_30 vdout0_30ck154 = 0 time = 1550
* CHECK dout0_31 vdout0_31ck154 = 0 time = 1550
* CHECK dout1_0 vdout1_0ck156 = 1.8 time = 1570
* CHECK dout1_1 vdout1_1ck156 = 0 time = 1570
* CHECK dout1_2 vdout1_2ck156 = 0 time = 1570
* CHECK dout1_3 vdout1_3ck156 = 0 time = 1570
* CHECK dout1_4 vdout1_4ck156 = 0 time = 1570
* CHECK dout1_5 vdout1_5ck156 = 1.8 time = 1570
* CHECK dout1_6 vdout1_6ck156 = 0 time = 1570
* CHECK dout1_7 vdout1_7ck156 = 1.8 time = 1570
* CHECK dout1_8 vdout1_8ck156 = 0 time = 1570
* CHECK dout1_9 vdout1_9ck156 = 1.8 time = 1570
* CHECK dout1_10 vdout1_10ck156 = 0 time = 1570
* CHECK dout1_11 vdout1_11ck156 = 0 time = 1570
* CHECK dout1_12 vdout1_12ck156 = 0 time = 1570
* CHECK dout1_13 vdout1_13ck156 = 0 time = 1570
* CHECK dout1_14 vdout1_14ck156 = 1.8 time = 1570
* CHECK dout1_15 vdout1_15ck156 = 1.8 time = 1570
* CHECK dout1_16 vdout1_16ck156 = 1.8 time = 1570
* CHECK dout1_17 vdout1_17ck156 = 0 time = 1570
* CHECK dout1_18 vdout1_18ck156 = 1.8 time = 1570
* CHECK dout1_19 vdout1_19ck156 = 0 time = 1570
* CHECK dout1_20 vdout1_20ck156 = 0 time = 1570
* CHECK dout1_21 vdout1_21ck156 = 0 time = 1570
* CHECK dout1_22 vdout1_22ck156 = 0 time = 1570
* CHECK dout1_23 vdout1_23ck156 = 0 time = 1570
* CHECK dout1_24 vdout1_24ck156 = 0 time = 1570
* CHECK dout1_25 vdout1_25ck156 = 1.8 time = 1570
* CHECK dout1_26 vdout1_26ck156 = 1.8 time = 1570
* CHECK dout1_27 vdout1_27ck156 = 0 time = 1570
* CHECK dout1_28 vdout1_28ck156 = 1.8 time = 1570
* CHECK dout1_29 vdout1_29ck156 = 0 time = 1570
* CHECK dout1_30 vdout1_30ck156 = 0 time = 1570
* CHECK dout1_31 vdout1_31ck156 = 0 time = 1570
* CHECK dout0_0 vdout0_0ck157 = 1.8 time = 1580
* CHECK dout0_1 vdout0_1ck157 = 0 time = 1580
* CHECK dout0_2 vdout0_2ck157 = 0 time = 1580
* CHECK dout0_3 vdout0_3ck157 = 1.8 time = 1580
* CHECK dout0_4 vdout0_4ck157 = 0 time = 1580
* CHECK dout0_5 vdout0_5ck157 = 1.8 time = 1580
* CHECK dout0_6 vdout0_6ck157 = 1.8 time = 1580
* CHECK dout0_7 vdout0_7ck157 = 0 time = 1580
* CHECK dout0_8 vdout0_8ck157 = 0 time = 1580
* CHECK dout0_9 vdout0_9ck157 = 1.8 time = 1580
* CHECK dout0_10 vdout0_10ck157 = 1.8 time = 1580
* CHECK dout0_11 vdout0_11ck157 = 1.8 time = 1580
* CHECK dout0_12 vdout0_12ck157 = 0 time = 1580
* CHECK dout0_13 vdout0_13ck157 = 0 time = 1580
* CHECK dout0_14 vdout0_14ck157 = 0 time = 1580
* CHECK dout0_15 vdout0_15ck157 = 0 time = 1580
* CHECK dout0_16 vdout0_16ck157 = 0 time = 1580
* CHECK dout0_17 vdout0_17ck157 = 1.8 time = 1580
* CHECK dout0_18 vdout0_18ck157 = 0 time = 1580
* CHECK dout0_19 vdout0_19ck157 = 1.8 time = 1580
* CHECK dout0_20 vdout0_20ck157 = 0 time = 1580
* CHECK dout0_21 vdout0_21ck157 = 0 time = 1580
* CHECK dout0_22 vdout0_22ck157 = 1.8 time = 1580
* CHECK dout0_23 vdout0_23ck157 = 0 time = 1580
* CHECK dout0_24 vdout0_24ck157 = 0 time = 1580
* CHECK dout0_25 vdout0_25ck157 = 1.8 time = 1580
* CHECK dout0_26 vdout0_26ck157 = 0 time = 1580
* CHECK dout0_27 vdout0_27ck157 = 0 time = 1580
* CHECK dout0_28 vdout0_28ck157 = 0 time = 1580
* CHECK dout0_29 vdout0_29ck157 = 0 time = 1580
* CHECK dout0_30 vdout0_30ck157 = 0 time = 1580
* CHECK dout0_31 vdout0_31ck157 = 1.8 time = 1580
* CHECK dout0_0 vdout0_0ck158 = 0 time = 1590
* CHECK dout0_1 vdout0_1ck158 = 1.8 time = 1590
* CHECK dout0_2 vdout0_2ck158 = 1.8 time = 1590
* CHECK dout0_3 vdout0_3ck158 = 1.8 time = 1590
* CHECK dout0_4 vdout0_4ck158 = 0 time = 1590
* CHECK dout0_5 vdout0_5ck158 = 1.8 time = 1590
* CHECK dout0_6 vdout0_6ck158 = 1.8 time = 1590
* CHECK dout0_7 vdout0_7ck158 = 1.8 time = 1590
* CHECK dout0_8 vdout0_8ck158 = 0 time = 1590
* CHECK dout0_9 vdout0_9ck158 = 0 time = 1590
* CHECK dout0_10 vdout0_10ck158 = 1.8 time = 1590
* CHECK dout0_11 vdout0_11ck158 = 1.8 time = 1590
* CHECK dout0_12 vdout0_12ck158 = 0 time = 1590
* CHECK dout0_13 vdout0_13ck158 = 1.8 time = 1590
* CHECK dout0_14 vdout0_14ck158 = 1.8 time = 1590
* CHECK dout0_15 vdout0_15ck158 = 0 time = 1590
* CHECK dout0_16 vdout0_16ck158 = 1.8 time = 1590
* CHECK dout0_17 vdout0_17ck158 = 0 time = 1590
* CHECK dout0_18 vdout0_18ck158 = 1.8 time = 1590
* CHECK dout0_19 vdout0_19ck158 = 0 time = 1590
* CHECK dout0_20 vdout0_20ck158 = 0 time = 1590
* CHECK dout0_21 vdout0_21ck158 = 1.8 time = 1590
* CHECK dout0_22 vdout0_22ck158 = 1.8 time = 1590
* CHECK dout0_23 vdout0_23ck158 = 0 time = 1590
* CHECK dout0_24 vdout0_24ck158 = 1.8 time = 1590
* CHECK dout0_25 vdout0_25ck158 = 0 time = 1590
* CHECK dout0_26 vdout0_26ck158 = 1.8 time = 1590
* CHECK dout0_27 vdout0_27ck158 = 0 time = 1590
* CHECK dout0_28 vdout0_28ck158 = 1.8 time = 1590
* CHECK dout0_29 vdout0_29ck158 = 0 time = 1590
* CHECK dout0_30 vdout0_30ck158 = 0 time = 1590
* CHECK dout0_31 vdout0_31ck158 = 0 time = 1590
* CHECK dout1_0 vdout1_0ck158 = 1.8 time = 1590
* CHECK dout1_1 vdout1_1ck158 = 0 time = 1590
* CHECK dout1_2 vdout1_2ck158 = 0 time = 1590
* CHECK dout1_3 vdout1_3ck158 = 0 time = 1590
* CHECK dout1_4 vdout1_4ck158 = 0 time = 1590
* CHECK dout1_5 vdout1_5ck158 = 1.8 time = 1590
* CHECK dout1_6 vdout1_6ck158 = 0 time = 1590
* CHECK dout1_7 vdout1_7ck158 = 1.8 time = 1590
* CHECK dout1_8 vdout1_8ck158 = 0 time = 1590
* CHECK dout1_9 vdout1_9ck158 = 1.8 time = 1590
* CHECK dout1_10 vdout1_10ck158 = 0 time = 1590
* CHECK dout1_11 vdout1_11ck158 = 0 time = 1590
* CHECK dout1_12 vdout1_12ck158 = 0 time = 1590
* CHECK dout1_13 vdout1_13ck158 = 0 time = 1590
* CHECK dout1_14 vdout1_14ck158 = 1.8 time = 1590
* CHECK dout1_15 vdout1_15ck158 = 1.8 time = 1590
* CHECK dout1_16 vdout1_16ck158 = 1.8 time = 1590
* CHECK dout1_17 vdout1_17ck158 = 0 time = 1590
* CHECK dout1_18 vdout1_18ck158 = 1.8 time = 1590
* CHECK dout1_19 vdout1_19ck158 = 0 time = 1590
* CHECK dout1_20 vdout1_20ck158 = 0 time = 1590
* CHECK dout1_21 vdout1_21ck158 = 0 time = 1590
* CHECK dout1_22 vdout1_22ck158 = 0 time = 1590
* CHECK dout1_23 vdout1_23ck158 = 0 time = 1590
* CHECK dout1_24 vdout1_24ck158 = 0 time = 1590
* CHECK dout1_25 vdout1_25ck158 = 1.8 time = 1590
* CHECK dout1_26 vdout1_26ck158 = 1.8 time = 1590
* CHECK dout1_27 vdout1_27ck158 = 0 time = 1590
* CHECK dout1_28 vdout1_28ck158 = 1.8 time = 1590
* CHECK dout1_29 vdout1_29ck158 = 0 time = 1590
* CHECK dout1_30 vdout1_30ck158 = 0 time = 1590
* CHECK dout1_31 vdout1_31ck158 = 0 time = 1590
* CHECK dout0_0 vdout0_0ck160 = 1.8 time = 1610
* CHECK dout0_1 vdout0_1ck160 = 0 time = 1610
* CHECK dout0_2 vdout0_2ck160 = 0 time = 1610
* CHECK dout0_3 vdout0_3ck160 = 1.8 time = 1610
* CHECK dout0_4 vdout0_4ck160 = 1.8 time = 1610
* CHECK dout0_5 vdout0_5ck160 = 0 time = 1610
* CHECK dout0_6 vdout0_6ck160 = 1.8 time = 1610
* CHECK dout0_7 vdout0_7ck160 = 1.8 time = 1610
* CHECK dout0_8 vdout0_8ck160 = 0 time = 1610
* CHECK dout0_9 vdout0_9ck160 = 1.8 time = 1610
* CHECK dout0_10 vdout0_10ck160 = 0 time = 1610
* CHECK dout0_11 vdout0_11ck160 = 0 time = 1610
* CHECK dout0_12 vdout0_12ck160 = 0 time = 1610
* CHECK dout0_13 vdout0_13ck160 = 1.8 time = 1610
* CHECK dout0_14 vdout0_14ck160 = 1.8 time = 1610
* CHECK dout0_15 vdout0_15ck160 = 1.8 time = 1610
* CHECK dout0_16 vdout0_16ck160 = 0 time = 1610
* CHECK dout0_17 vdout0_17ck160 = 0 time = 1610
* CHECK dout0_18 vdout0_18ck160 = 1.8 time = 1610
* CHECK dout0_19 vdout0_19ck160 = 1.8 time = 1610
* CHECK dout0_20 vdout0_20ck160 = 0 time = 1610
* CHECK dout0_21 vdout0_21ck160 = 1.8 time = 1610
* CHECK dout0_22 vdout0_22ck160 = 0 time = 1610
* CHECK dout0_23 vdout0_23ck160 = 0 time = 1610
* CHECK dout0_24 vdout0_24ck160 = 0 time = 1610
* CHECK dout0_25 vdout0_25ck160 = 0 time = 1610
* CHECK dout0_26 vdout0_26ck160 = 0 time = 1610
* CHECK dout0_27 vdout0_27ck160 = 0 time = 1610
* CHECK dout0_28 vdout0_28ck160 = 1.8 time = 1610
* CHECK dout0_29 vdout0_29ck160 = 0 time = 1610
* CHECK dout0_30 vdout0_30ck160 = 1.8 time = 1610
* CHECK dout0_31 vdout0_31ck160 = 1.8 time = 1610
* CHECK dout0_0 vdout0_0ck162 = 0 time = 1630
* CHECK dout0_1 vdout0_1ck162 = 0 time = 1630
* CHECK dout0_2 vdout0_2ck162 = 1.8 time = 1630
* CHECK dout0_3 vdout0_3ck162 = 0 time = 1630
* CHECK dout0_4 vdout0_4ck162 = 0 time = 1630
* CHECK dout0_5 vdout0_5ck162 = 0 time = 1630
* CHECK dout0_6 vdout0_6ck162 = 1.8 time = 1630
* CHECK dout0_7 vdout0_7ck162 = 1.8 time = 1630
* CHECK dout0_8 vdout0_8ck162 = 1.8 time = 1630
* CHECK dout0_9 vdout0_9ck162 = 1.8 time = 1630
* CHECK dout0_10 vdout0_10ck162 = 0 time = 1630
* CHECK dout0_11 vdout0_11ck162 = 0 time = 1630
* CHECK dout0_12 vdout0_12ck162 = 1.8 time = 1630
* CHECK dout0_13 vdout0_13ck162 = 0 time = 1630
* CHECK dout0_14 vdout0_14ck162 = 0 time = 1630
* CHECK dout0_15 vdout0_15ck162 = 0 time = 1630
* CHECK dout0_16 vdout0_16ck162 = 0 time = 1630
* CHECK dout0_17 vdout0_17ck162 = 1.8 time = 1630
* CHECK dout0_18 vdout0_18ck162 = 0 time = 1630
* CHECK dout0_19 vdout0_19ck162 = 1.8 time = 1630
* CHECK dout0_20 vdout0_20ck162 = 1.8 time = 1630
* CHECK dout0_21 vdout0_21ck162 = 0 time = 1630
* CHECK dout0_22 vdout0_22ck162 = 1.8 time = 1630
* CHECK dout0_23 vdout0_23ck162 = 0 time = 1630
* CHECK dout0_24 vdout0_24ck162 = 0 time = 1630
* CHECK dout0_25 vdout0_25ck162 = 1.8 time = 1630
* CHECK dout0_26 vdout0_26ck162 = 0 time = 1630
* CHECK dout0_27 vdout0_27ck162 = 1.8 time = 1630
* CHECK dout0_28 vdout0_28ck162 = 0 time = 1630
* CHECK dout0_29 vdout0_29ck162 = 0 time = 1630
* CHECK dout0_30 vdout0_30ck162 = 0 time = 1630
* CHECK dout0_31 vdout0_31ck162 = 1.8 time = 1630
* CHECK dout1_0 vdout1_0ck162 = 0 time = 1630
* CHECK dout1_1 vdout1_1ck162 = 1.8 time = 1630
* CHECK dout1_2 vdout1_2ck162 = 1.8 time = 1630
* CHECK dout1_3 vdout1_3ck162 = 1.8 time = 1630
* CHECK dout1_4 vdout1_4ck162 = 0 time = 1630
* CHECK dout1_5 vdout1_5ck162 = 0 time = 1630
* CHECK dout1_6 vdout1_6ck162 = 0 time = 1630
* CHECK dout1_7 vdout1_7ck162 = 1.8 time = 1630
* CHECK dout1_8 vdout1_8ck162 = 0 time = 1630
* CHECK dout1_9 vdout1_9ck162 = 0 time = 1630
* CHECK dout1_10 vdout1_10ck162 = 1.8 time = 1630
* CHECK dout1_11 vdout1_11ck162 = 1.8 time = 1630
* CHECK dout1_12 vdout1_12ck162 = 1.8 time = 1630
* CHECK dout1_13 vdout1_13ck162 = 0 time = 1630
* CHECK dout1_14 vdout1_14ck162 = 1.8 time = 1630
* CHECK dout1_15 vdout1_15ck162 = 1.8 time = 1630
* CHECK dout1_16 vdout1_16ck162 = 1.8 time = 1630
* CHECK dout1_17 vdout1_17ck162 = 0 time = 1630
* CHECK dout1_18 vdout1_18ck162 = 1.8 time = 1630
* CHECK dout1_19 vdout1_19ck162 = 0 time = 1630
* CHECK dout1_20 vdout1_20ck162 = 1.8 time = 1630
* CHECK dout1_21 vdout1_21ck162 = 1.8 time = 1630
* CHECK dout1_22 vdout1_22ck162 = 1.8 time = 1630
* CHECK dout1_23 vdout1_23ck162 = 0 time = 1630
* CHECK dout1_24 vdout1_24ck162 = 0 time = 1630
* CHECK dout1_25 vdout1_25ck162 = 1.8 time = 1630
* CHECK dout1_26 vdout1_26ck162 = 0 time = 1630
* CHECK dout1_27 vdout1_27ck162 = 0 time = 1630
* CHECK dout1_28 vdout1_28ck162 = 1.8 time = 1630
* CHECK dout1_29 vdout1_29ck162 = 1.8 time = 1630
* CHECK dout1_30 vdout1_30ck162 = 1.8 time = 1630
* CHECK dout1_31 vdout1_31ck162 = 0 time = 1630
* CHECK dout0_0 vdout0_0ck163 = 1.8 time = 1640
* CHECK dout0_1 vdout0_1ck163 = 1.8 time = 1640
* CHECK dout0_2 vdout0_2ck163 = 1.8 time = 1640
* CHECK dout0_3 vdout0_3ck163 = 0 time = 1640
* CHECK dout0_4 vdout0_4ck163 = 1.8 time = 1640
* CHECK dout0_5 vdout0_5ck163 = 1.8 time = 1640
* CHECK dout0_6 vdout0_6ck163 = 0 time = 1640
* CHECK dout0_7 vdout0_7ck163 = 1.8 time = 1640
* CHECK dout0_8 vdout0_8ck163 = 1.8 time = 1640
* CHECK dout0_9 vdout0_9ck163 = 0 time = 1640
* CHECK dout0_10 vdout0_10ck163 = 0 time = 1640
* CHECK dout0_11 vdout0_11ck163 = 0 time = 1640
* CHECK dout0_12 vdout0_12ck163 = 1.8 time = 1640
* CHECK dout0_13 vdout0_13ck163 = 0 time = 1640
* CHECK dout0_14 vdout0_14ck163 = 0 time = 1640
* CHECK dout0_15 vdout0_15ck163 = 1.8 time = 1640
* CHECK dout0_16 vdout0_16ck163 = 1.8 time = 1640
* CHECK dout0_17 vdout0_17ck163 = 1.8 time = 1640
* CHECK dout0_18 vdout0_18ck163 = 1.8 time = 1640
* CHECK dout0_19 vdout0_19ck163 = 1.8 time = 1640
* CHECK dout0_20 vdout0_20ck163 = 1.8 time = 1640
* CHECK dout0_21 vdout0_21ck163 = 0 time = 1640
* CHECK dout0_22 vdout0_22ck163 = 0 time = 1640
* CHECK dout0_23 vdout0_23ck163 = 0 time = 1640
* CHECK dout0_24 vdout0_24ck163 = 1.8 time = 1640
* CHECK dout0_25 vdout0_25ck163 = 1.8 time = 1640
* CHECK dout0_26 vdout0_26ck163 = 0 time = 1640
* CHECK dout0_27 vdout0_27ck163 = 0 time = 1640
* CHECK dout0_28 vdout0_28ck163 = 0 time = 1640
* CHECK dout0_29 vdout0_29ck163 = 0 time = 1640
* CHECK dout0_30 vdout0_30ck163 = 1.8 time = 1640
* CHECK dout0_31 vdout0_31ck163 = 1.8 time = 1640
* CHECK dout1_0 vdout1_0ck164 = 1.8 time = 1650
* CHECK dout1_1 vdout1_1ck164 = 1.8 time = 1650
* CHECK dout1_2 vdout1_2ck164 = 1.8 time = 1650
* CHECK dout1_3 vdout1_3ck164 = 0 time = 1650
* CHECK dout1_4 vdout1_4ck164 = 1.8 time = 1650
* CHECK dout1_5 vdout1_5ck164 = 1.8 time = 1650
* CHECK dout1_6 vdout1_6ck164 = 0 time = 1650
* CHECK dout1_7 vdout1_7ck164 = 1.8 time = 1650
* CHECK dout1_8 vdout1_8ck164 = 1.8 time = 1650
* CHECK dout1_9 vdout1_9ck164 = 0 time = 1650
* CHECK dout1_10 vdout1_10ck164 = 0 time = 1650
* CHECK dout1_11 vdout1_11ck164 = 0 time = 1650
* CHECK dout1_12 vdout1_12ck164 = 1.8 time = 1650
* CHECK dout1_13 vdout1_13ck164 = 0 time = 1650
* CHECK dout1_14 vdout1_14ck164 = 0 time = 1650
* CHECK dout1_15 vdout1_15ck164 = 1.8 time = 1650
* CHECK dout1_16 vdout1_16ck164 = 1.8 time = 1650
* CHECK dout1_17 vdout1_17ck164 = 1.8 time = 1650
* CHECK dout1_18 vdout1_18ck164 = 1.8 time = 1650
* CHECK dout1_19 vdout1_19ck164 = 1.8 time = 1650
* CHECK dout1_20 vdout1_20ck164 = 1.8 time = 1650
* CHECK dout1_21 vdout1_21ck164 = 0 time = 1650
* CHECK dout1_22 vdout1_22ck164 = 0 time = 1650
* CHECK dout1_23 vdout1_23ck164 = 0 time = 1650
* CHECK dout1_24 vdout1_24ck164 = 1.8 time = 1650
* CHECK dout1_25 vdout1_25ck164 = 1.8 time = 1650
* CHECK dout1_26 vdout1_26ck164 = 0 time = 1650
* CHECK dout1_27 vdout1_27ck164 = 0 time = 1650
* CHECK dout1_28 vdout1_28ck164 = 0 time = 1650
* CHECK dout1_29 vdout1_29ck164 = 0 time = 1650
* CHECK dout1_30 vdout1_30ck164 = 1.8 time = 1650
* CHECK dout1_31 vdout1_31ck164 = 1.8 time = 1650
* CHECK dout0_0 vdout0_0ck165 = 0 time = 1660
* CHECK dout0_1 vdout0_1ck165 = 1.8 time = 1660
* CHECK dout0_2 vdout0_2ck165 = 1.8 time = 1660
* CHECK dout0_3 vdout0_3ck165 = 1.8 time = 1660
* CHECK dout0_4 vdout0_4ck165 = 0 time = 1660
* CHECK dout0_5 vdout0_5ck165 = 1.8 time = 1660
* CHECK dout0_6 vdout0_6ck165 = 1.8 time = 1660
* CHECK dout0_7 vdout0_7ck165 = 1.8 time = 1660
* CHECK dout0_8 vdout0_8ck165 = 0 time = 1660
* CHECK dout0_9 vdout0_9ck165 = 0 time = 1660
* CHECK dout0_10 vdout0_10ck165 = 1.8 time = 1660
* CHECK dout0_11 vdout0_11ck165 = 1.8 time = 1660
* CHECK dout0_12 vdout0_12ck165 = 0 time = 1660
* CHECK dout0_13 vdout0_13ck165 = 1.8 time = 1660
* CHECK dout0_14 vdout0_14ck165 = 1.8 time = 1660
* CHECK dout0_15 vdout0_15ck165 = 0 time = 1660
* CHECK dout0_16 vdout0_16ck165 = 1.8 time = 1660
* CHECK dout0_17 vdout0_17ck165 = 0 time = 1660
* CHECK dout0_18 vdout0_18ck165 = 1.8 time = 1660
* CHECK dout0_19 vdout0_19ck165 = 0 time = 1660
* CHECK dout0_20 vdout0_20ck165 = 0 time = 1660
* CHECK dout0_21 vdout0_21ck165 = 1.8 time = 1660
* CHECK dout0_22 vdout0_22ck165 = 1.8 time = 1660
* CHECK dout0_23 vdout0_23ck165 = 0 time = 1660
* CHECK dout0_24 vdout0_24ck165 = 1.8 time = 1660
* CHECK dout0_25 vdout0_25ck165 = 0 time = 1660
* CHECK dout0_26 vdout0_26ck165 = 1.8 time = 1660
* CHECK dout0_27 vdout0_27ck165 = 0 time = 1660
* CHECK dout0_28 vdout0_28ck165 = 1.8 time = 1660
* CHECK dout0_29 vdout0_29ck165 = 0 time = 1660
* CHECK dout0_30 vdout0_30ck165 = 0 time = 1660
* CHECK dout0_31 vdout0_31ck165 = 0 time = 1660
* CHECK dout1_0 vdout1_0ck165 = 0 time = 1660
* CHECK dout1_1 vdout1_1ck165 = 1.8 time = 1660
* CHECK dout1_2 vdout1_2ck165 = 1.8 time = 1660
* CHECK dout1_3 vdout1_3ck165 = 1.8 time = 1660
* CHECK dout1_4 vdout1_4ck165 = 0 time = 1660
* CHECK dout1_5 vdout1_5ck165 = 0 time = 1660
* CHECK dout1_6 vdout1_6ck165 = 0 time = 1660
* CHECK dout1_7 vdout1_7ck165 = 1.8 time = 1660
* CHECK dout1_8 vdout1_8ck165 = 0 time = 1660
* CHECK dout1_9 vdout1_9ck165 = 0 time = 1660
* CHECK dout1_10 vdout1_10ck165 = 1.8 time = 1660
* CHECK dout1_11 vdout1_11ck165 = 1.8 time = 1660
* CHECK dout1_12 vdout1_12ck165 = 1.8 time = 1660
* CHECK dout1_13 vdout1_13ck165 = 0 time = 1660
* CHECK dout1_14 vdout1_14ck165 = 1.8 time = 1660
* CHECK dout1_15 vdout1_15ck165 = 1.8 time = 1660
* CHECK dout1_16 vdout1_16ck165 = 1.8 time = 1660
* CHECK dout1_17 vdout1_17ck165 = 0 time = 1660
* CHECK dout1_18 vdout1_18ck165 = 1.8 time = 1660
* CHECK dout1_19 vdout1_19ck165 = 0 time = 1660
* CHECK dout1_20 vdout1_20ck165 = 1.8 time = 1660
* CHECK dout1_21 vdout1_21ck165 = 1.8 time = 1660
* CHECK dout1_22 vdout1_22ck165 = 1.8 time = 1660
* CHECK dout1_23 vdout1_23ck165 = 0 time = 1660
* CHECK dout1_24 vdout1_24ck165 = 0 time = 1660
* CHECK dout1_25 vdout1_25ck165 = 1.8 time = 1660
* CHECK dout1_26 vdout1_26ck165 = 0 time = 1660
* CHECK dout1_27 vdout1_27ck165 = 0 time = 1660
* CHECK dout1_28 vdout1_28ck165 = 1.8 time = 1660
* CHECK dout1_29 vdout1_29ck165 = 1.8 time = 1660
* CHECK dout1_30 vdout1_30ck165 = 1.8 time = 1660
* CHECK dout1_31 vdout1_31ck165 = 0 time = 1660
* CHECK dout0_0 vdout0_0ck166 = 1.8 time = 1670
* CHECK dout0_1 vdout0_1ck166 = 0 time = 1670
* CHECK dout0_2 vdout0_2ck166 = 0 time = 1670
* CHECK dout0_3 vdout0_3ck166 = 1.8 time = 1670
* CHECK dout0_4 vdout0_4ck166 = 1.8 time = 1670
* CHECK dout0_5 vdout0_5ck166 = 0 time = 1670
* CHECK dout0_6 vdout0_6ck166 = 1.8 time = 1670
* CHECK dout0_7 vdout0_7ck166 = 1.8 time = 1670
* CHECK dout0_8 vdout0_8ck166 = 0 time = 1670
* CHECK dout0_9 vdout0_9ck166 = 1.8 time = 1670
* CHECK dout0_10 vdout0_10ck166 = 0 time = 1670
* CHECK dout0_11 vdout0_11ck166 = 0 time = 1670
* CHECK dout0_12 vdout0_12ck166 = 0 time = 1670
* CHECK dout0_13 vdout0_13ck166 = 1.8 time = 1670
* CHECK dout0_14 vdout0_14ck166 = 1.8 time = 1670
* CHECK dout0_15 vdout0_15ck166 = 1.8 time = 1670
* CHECK dout0_16 vdout0_16ck166 = 1.8 time = 1670
* CHECK dout0_17 vdout0_17ck166 = 1.8 time = 1670
* CHECK dout0_18 vdout0_18ck166 = 1.8 time = 1670
* CHECK dout0_19 vdout0_19ck166 = 1.8 time = 1670
* CHECK dout0_20 vdout0_20ck166 = 1.8 time = 1670
* CHECK dout0_21 vdout0_21ck166 = 0 time = 1670
* CHECK dout0_22 vdout0_22ck166 = 1.8 time = 1670
* CHECK dout0_23 vdout0_23ck166 = 1.8 time = 1670
* CHECK dout0_24 vdout0_24ck166 = 0 time = 1670
* CHECK dout0_25 vdout0_25ck166 = 0 time = 1670
* CHECK dout0_26 vdout0_26ck166 = 0 time = 1670
* CHECK dout0_27 vdout0_27ck166 = 0 time = 1670
* CHECK dout0_28 vdout0_28ck166 = 1.8 time = 1670
* CHECK dout0_29 vdout0_29ck166 = 0 time = 1670
* CHECK dout0_30 vdout0_30ck166 = 1.8 time = 1670
* CHECK dout0_31 vdout0_31ck166 = 1.8 time = 1670
* CHECK dout1_0 vdout1_0ck166 = 0 time = 1670
* CHECK dout1_1 vdout1_1ck166 = 1.8 time = 1670
* CHECK dout1_2 vdout1_2ck166 = 1.8 time = 1670
* CHECK dout1_3 vdout1_3ck166 = 1.8 time = 1670
* CHECK dout1_4 vdout1_4ck166 = 0 time = 1670
* CHECK dout1_5 vdout1_5ck166 = 0 time = 1670
* CHECK dout1_6 vdout1_6ck166 = 0 time = 1670
* CHECK dout1_7 vdout1_7ck166 = 1.8 time = 1670
* CHECK dout1_8 vdout1_8ck166 = 0 time = 1670
* CHECK dout1_9 vdout1_9ck166 = 0 time = 1670
* CHECK dout1_10 vdout1_10ck166 = 1.8 time = 1670
* CHECK dout1_11 vdout1_11ck166 = 1.8 time = 1670
* CHECK dout1_12 vdout1_12ck166 = 1.8 time = 1670
* CHECK dout1_13 vdout1_13ck166 = 0 time = 1670
* CHECK dout1_14 vdout1_14ck166 = 1.8 time = 1670
* CHECK dout1_15 vdout1_15ck166 = 1.8 time = 1670
* CHECK dout1_16 vdout1_16ck166 = 1.8 time = 1670
* CHECK dout1_17 vdout1_17ck166 = 0 time = 1670
* CHECK dout1_18 vdout1_18ck166 = 1.8 time = 1670
* CHECK dout1_19 vdout1_19ck166 = 0 time = 1670
* CHECK dout1_20 vdout1_20ck166 = 1.8 time = 1670
* CHECK dout1_21 vdout1_21ck166 = 1.8 time = 1670
* CHECK dout1_22 vdout1_22ck166 = 1.8 time = 1670
* CHECK dout1_23 vdout1_23ck166 = 0 time = 1670
* CHECK dout1_24 vdout1_24ck166 = 0 time = 1670
* CHECK dout1_25 vdout1_25ck166 = 1.8 time = 1670
* CHECK dout1_26 vdout1_26ck166 = 0 time = 1670
* CHECK dout1_27 vdout1_27ck166 = 0 time = 1670
* CHECK dout1_28 vdout1_28ck166 = 1.8 time = 1670
* CHECK dout1_29 vdout1_29ck166 = 1.8 time = 1670
* CHECK dout1_30 vdout1_30ck166 = 1.8 time = 1670
* CHECK dout1_31 vdout1_31ck166 = 0 time = 1670
* CHECK dout0_0 vdout0_0ck167 = 0 time = 1680
* CHECK dout0_1 vdout0_1ck167 = 0 time = 1680
* CHECK dout0_2 vdout0_2ck167 = 1.8 time = 1680
* CHECK dout0_3 vdout0_3ck167 = 0 time = 1680
* CHECK dout0_4 vdout0_4ck167 = 0 time = 1680
* CHECK dout0_5 vdout0_5ck167 = 0 time = 1680
* CHECK dout0_6 vdout0_6ck167 = 1.8 time = 1680
* CHECK dout0_7 vdout0_7ck167 = 1.8 time = 1680
* CHECK dout0_8 vdout0_8ck167 = 1.8 time = 1680
* CHECK dout0_9 vdout0_9ck167 = 1.8 time = 1680
* CHECK dout0_10 vdout0_10ck167 = 0 time = 1680
* CHECK dout0_11 vdout0_11ck167 = 0 time = 1680
* CHECK dout0_12 vdout0_12ck167 = 1.8 time = 1680
* CHECK dout0_13 vdout0_13ck167 = 0 time = 1680
* CHECK dout0_14 vdout0_14ck167 = 0 time = 1680
* CHECK dout0_15 vdout0_15ck167 = 0 time = 1680
* CHECK dout0_16 vdout0_16ck167 = 0 time = 1680
* CHECK dout0_17 vdout0_17ck167 = 1.8 time = 1680
* CHECK dout0_18 vdout0_18ck167 = 0 time = 1680
* CHECK dout0_19 vdout0_19ck167 = 1.8 time = 1680
* CHECK dout0_20 vdout0_20ck167 = 1.8 time = 1680
* CHECK dout0_21 vdout0_21ck167 = 0 time = 1680
* CHECK dout0_22 vdout0_22ck167 = 1.8 time = 1680
* CHECK dout0_23 vdout0_23ck167 = 0 time = 1680
* CHECK dout0_24 vdout0_24ck167 = 0 time = 1680
* CHECK dout0_25 vdout0_25ck167 = 1.8 time = 1680
* CHECK dout0_26 vdout0_26ck167 = 0 time = 1680
* CHECK dout0_27 vdout0_27ck167 = 1.8 time = 1680
* CHECK dout0_28 vdout0_28ck167 = 0 time = 1680
* CHECK dout0_29 vdout0_29ck167 = 0 time = 1680
* CHECK dout0_30 vdout0_30ck167 = 0 time = 1680
* CHECK dout0_31 vdout0_31ck167 = 1.8 time = 1680
* CHECK dout0_0 vdout0_0ck168 = 0 time = 1690
* CHECK dout0_1 vdout0_1ck168 = 0 time = 1690
* CHECK dout0_2 vdout0_2ck168 = 1.8 time = 1690
* CHECK dout0_3 vdout0_3ck168 = 0 time = 1690
* CHECK dout0_4 vdout0_4ck168 = 0 time = 1690
* CHECK dout0_5 vdout0_5ck168 = 0 time = 1690
* CHECK dout0_6 vdout0_6ck168 = 1.8 time = 1690
* CHECK dout0_7 vdout0_7ck168 = 1.8 time = 1690
* CHECK dout0_8 vdout0_8ck168 = 1.8 time = 1690
* CHECK dout0_9 vdout0_9ck168 = 1.8 time = 1690
* CHECK dout0_10 vdout0_10ck168 = 0 time = 1690
* CHECK dout0_11 vdout0_11ck168 = 0 time = 1690
* CHECK dout0_12 vdout0_12ck168 = 1.8 time = 1690
* CHECK dout0_13 vdout0_13ck168 = 0 time = 1690
* CHECK dout0_14 vdout0_14ck168 = 0 time = 1690
* CHECK dout0_15 vdout0_15ck168 = 0 time = 1690
* CHECK dout0_16 vdout0_16ck168 = 0 time = 1690
* CHECK dout0_17 vdout0_17ck168 = 1.8 time = 1690
* CHECK dout0_18 vdout0_18ck168 = 0 time = 1690
* CHECK dout0_19 vdout0_19ck168 = 1.8 time = 1690
* CHECK dout0_20 vdout0_20ck168 = 1.8 time = 1690
* CHECK dout0_21 vdout0_21ck168 = 0 time = 1690
* CHECK dout0_22 vdout0_22ck168 = 1.8 time = 1690
* CHECK dout0_23 vdout0_23ck168 = 0 time = 1690
* CHECK dout0_24 vdout0_24ck168 = 0 time = 1690
* CHECK dout0_25 vdout0_25ck168 = 1.8 time = 1690
* CHECK dout0_26 vdout0_26ck168 = 0 time = 1690
* CHECK dout0_27 vdout0_27ck168 = 1.8 time = 1690
* CHECK dout0_28 vdout0_28ck168 = 0 time = 1690
* CHECK dout0_29 vdout0_29ck168 = 0 time = 1690
* CHECK dout0_30 vdout0_30ck168 = 0 time = 1690
* CHECK dout0_31 vdout0_31ck168 = 1.8 time = 1690
* CHECK dout1_0 vdout1_0ck168 = 1.8 time = 1690
* CHECK dout1_1 vdout1_1ck168 = 0 time = 1690
* CHECK dout1_2 vdout1_2ck168 = 0 time = 1690
* CHECK dout1_3 vdout1_3ck168 = 1.8 time = 1690
* CHECK dout1_4 vdout1_4ck168 = 0 time = 1690
* CHECK dout1_5 vdout1_5ck168 = 1.8 time = 1690
* CHECK dout1_6 vdout1_6ck168 = 0 time = 1690
* CHECK dout1_7 vdout1_7ck168 = 1.8 time = 1690
* CHECK dout1_8 vdout1_8ck168 = 1.8 time = 1690
* CHECK dout1_9 vdout1_9ck168 = 0 time = 1690
* CHECK dout1_10 vdout1_10ck168 = 0 time = 1690
* CHECK dout1_11 vdout1_11ck168 = 1.8 time = 1690
* CHECK dout1_12 vdout1_12ck168 = 1.8 time = 1690
* CHECK dout1_13 vdout1_13ck168 = 1.8 time = 1690
* CHECK dout1_14 vdout1_14ck168 = 1.8 time = 1690
* CHECK dout1_15 vdout1_15ck168 = 0 time = 1690
* CHECK dout1_16 vdout1_16ck168 = 0 time = 1690
* CHECK dout1_17 vdout1_17ck168 = 0 time = 1690
* CHECK dout1_18 vdout1_18ck168 = 1.8 time = 1690
* CHECK dout1_19 vdout1_19ck168 = 1.8 time = 1690
* CHECK dout1_20 vdout1_20ck168 = 1.8 time = 1690
* CHECK dout1_21 vdout1_21ck168 = 1.8 time = 1690
* CHECK dout1_22 vdout1_22ck168 = 0 time = 1690
* CHECK dout1_23 vdout1_23ck168 = 1.8 time = 1690
* CHECK dout1_24 vdout1_24ck168 = 1.8 time = 1690
* CHECK dout1_25 vdout1_25ck168 = 1.8 time = 1690
* CHECK dout1_26 vdout1_26ck168 = 0 time = 1690
* CHECK dout1_27 vdout1_27ck168 = 1.8 time = 1690
* CHECK dout1_28 vdout1_28ck168 = 0 time = 1690
* CHECK dout1_29 vdout1_29ck168 = 0 time = 1690
* CHECK dout1_30 vdout1_30ck168 = 1.8 time = 1690
* CHECK dout1_31 vdout1_31ck168 = 0 time = 1690
* CHECK dout0_0 vdout0_0ck169 = 1.8 time = 1700
* CHECK dout0_1 vdout0_1ck169 = 0 time = 1700
* CHECK dout0_2 vdout0_2ck169 = 0 time = 1700
* CHECK dout0_3 vdout0_3ck169 = 1.8 time = 1700
* CHECK dout0_4 vdout0_4ck169 = 0 time = 1700
* CHECK dout0_5 vdout0_5ck169 = 1.8 time = 1700
* CHECK dout0_6 vdout0_6ck169 = 0 time = 1700
* CHECK dout0_7 vdout0_7ck169 = 1.8 time = 1700
* CHECK dout0_8 vdout0_8ck169 = 1.8 time = 1700
* CHECK dout0_9 vdout0_9ck169 = 0 time = 1700
* CHECK dout0_10 vdout0_10ck169 = 0 time = 1700
* CHECK dout0_11 vdout0_11ck169 = 1.8 time = 1700
* CHECK dout0_12 vdout0_12ck169 = 1.8 time = 1700
* CHECK dout0_13 vdout0_13ck169 = 1.8 time = 1700
* CHECK dout0_14 vdout0_14ck169 = 1.8 time = 1700
* CHECK dout0_15 vdout0_15ck169 = 0 time = 1700
* CHECK dout0_16 vdout0_16ck169 = 0 time = 1700
* CHECK dout0_17 vdout0_17ck169 = 0 time = 1700
* CHECK dout0_18 vdout0_18ck169 = 1.8 time = 1700
* CHECK dout0_19 vdout0_19ck169 = 1.8 time = 1700
* CHECK dout0_20 vdout0_20ck169 = 1.8 time = 1700
* CHECK dout0_21 vdout0_21ck169 = 1.8 time = 1700
* CHECK dout0_22 vdout0_22ck169 = 0 time = 1700
* CHECK dout0_23 vdout0_23ck169 = 1.8 time = 1700
* CHECK dout0_24 vdout0_24ck169 = 1.8 time = 1700
* CHECK dout0_25 vdout0_25ck169 = 1.8 time = 1700
* CHECK dout0_26 vdout0_26ck169 = 0 time = 1700
* CHECK dout0_27 vdout0_27ck169 = 1.8 time = 1700
* CHECK dout0_28 vdout0_28ck169 = 0 time = 1700
* CHECK dout0_29 vdout0_29ck169 = 0 time = 1700
* CHECK dout0_30 vdout0_30ck169 = 1.8 time = 1700
* CHECK dout0_31 vdout0_31ck169 = 0 time = 1700
* CHECK dout1_0 vdout1_0ck169 = 0 time = 1700
* CHECK dout1_1 vdout1_1ck169 = 1.8 time = 1700
* CHECK dout1_2 vdout1_2ck169 = 1.8 time = 1700
* CHECK dout1_3 vdout1_3ck169 = 1.8 time = 1700
* CHECK dout1_4 vdout1_4ck169 = 0 time = 1700
* CHECK dout1_5 vdout1_5ck169 = 1.8 time = 1700
* CHECK dout1_6 vdout1_6ck169 = 1.8 time = 1700
* CHECK dout1_7 vdout1_7ck169 = 1.8 time = 1700
* CHECK dout1_8 vdout1_8ck169 = 0 time = 1700
* CHECK dout1_9 vdout1_9ck169 = 0 time = 1700
* CHECK dout1_10 vdout1_10ck169 = 1.8 time = 1700
* CHECK dout1_11 vdout1_11ck169 = 1.8 time = 1700
* CHECK dout1_12 vdout1_12ck169 = 0 time = 1700
* CHECK dout1_13 vdout1_13ck169 = 1.8 time = 1700
* CHECK dout1_14 vdout1_14ck169 = 1.8 time = 1700
* CHECK dout1_15 vdout1_15ck169 = 0 time = 1700
* CHECK dout1_16 vdout1_16ck169 = 1.8 time = 1700
* CHECK dout1_17 vdout1_17ck169 = 0 time = 1700
* CHECK dout1_18 vdout1_18ck169 = 1.8 time = 1700
* CHECK dout1_19 vdout1_19ck169 = 0 time = 1700
* CHECK dout1_20 vdout1_20ck169 = 0 time = 1700
* CHECK dout1_21 vdout1_21ck169 = 1.8 time = 1700
* CHECK dout1_22 vdout1_22ck169 = 1.8 time = 1700
* CHECK dout1_23 vdout1_23ck169 = 0 time = 1700
* CHECK dout1_24 vdout1_24ck169 = 1.8 time = 1700
* CHECK dout1_25 vdout1_25ck169 = 0 time = 1700
* CHECK dout1_26 vdout1_26ck169 = 1.8 time = 1700
* CHECK dout1_27 vdout1_27ck169 = 0 time = 1700
* CHECK dout1_28 vdout1_28ck169 = 1.8 time = 1700
* CHECK dout1_29 vdout1_29ck169 = 0 time = 1700
* CHECK dout1_30 vdout1_30ck169 = 0 time = 1700
* CHECK dout1_31 vdout1_31ck169 = 0 time = 1700
* CHECK dout1_0 vdout1_0ck170 = 1.8 time = 1710
* CHECK dout1_1 vdout1_1ck170 = 0 time = 1710
* CHECK dout1_2 vdout1_2ck170 = 0 time = 1710
* CHECK dout1_3 vdout1_3ck170 = 1.8 time = 1710
* CHECK dout1_4 vdout1_4ck170 = 1.8 time = 1710
* CHECK dout1_5 vdout1_5ck170 = 0 time = 1710
* CHECK dout1_6 vdout1_6ck170 = 1.8 time = 1710
* CHECK dout1_7 vdout1_7ck170 = 1.8 time = 1710
* CHECK dout1_8 vdout1_8ck170 = 0 time = 1710
* CHECK dout1_9 vdout1_9ck170 = 1.8 time = 1710
* CHECK dout1_10 vdout1_10ck170 = 0 time = 1710
* CHECK dout1_11 vdout1_11ck170 = 0 time = 1710
* CHECK dout1_12 vdout1_12ck170 = 0 time = 1710
* CHECK dout1_13 vdout1_13ck170 = 1.8 time = 1710
* CHECK dout1_14 vdout1_14ck170 = 1.8 time = 1710
* CHECK dout1_15 vdout1_15ck170 = 1.8 time = 1710
* CHECK dout1_16 vdout1_16ck170 = 1.8 time = 1710
* CHECK dout1_17 vdout1_17ck170 = 1.8 time = 1710
* CHECK dout1_18 vdout1_18ck170 = 1.8 time = 1710
* CHECK dout1_19 vdout1_19ck170 = 1.8 time = 1710
* CHECK dout1_20 vdout1_20ck170 = 1.8 time = 1710
* CHECK dout1_21 vdout1_21ck170 = 0 time = 1710
* CHECK dout1_22 vdout1_22ck170 = 1.8 time = 1710
* CHECK dout1_23 vdout1_23ck170 = 1.8 time = 1710
* CHECK dout1_24 vdout1_24ck170 = 0 time = 1710
* CHECK dout1_25 vdout1_25ck170 = 0 time = 1710
* CHECK dout1_26 vdout1_26ck170 = 0 time = 1710
* CHECK dout1_27 vdout1_27ck170 = 0 time = 1710
* CHECK dout1_28 vdout1_28ck170 = 1.8 time = 1710
* CHECK dout1_29 vdout1_29ck170 = 0 time = 1710
* CHECK dout1_30 vdout1_30ck170 = 1.8 time = 1710
* CHECK dout1_31 vdout1_31ck170 = 1.8 time = 1710
* CHECK dout0_0 vdout0_0ck171 = 0 time = 1720
* CHECK dout0_1 vdout0_1ck171 = 0 time = 1720
* CHECK dout0_2 vdout0_2ck171 = 1.8 time = 1720
* CHECK dout0_3 vdout0_3ck171 = 0 time = 1720
* CHECK dout0_4 vdout0_4ck171 = 0 time = 1720
* CHECK dout0_5 vdout0_5ck171 = 0 time = 1720
* CHECK dout0_6 vdout0_6ck171 = 1.8 time = 1720
* CHECK dout0_7 vdout0_7ck171 = 1.8 time = 1720
* CHECK dout0_8 vdout0_8ck171 = 1.8 time = 1720
* CHECK dout0_9 vdout0_9ck171 = 1.8 time = 1720
* CHECK dout0_10 vdout0_10ck171 = 0 time = 1720
* CHECK dout0_11 vdout0_11ck171 = 0 time = 1720
* CHECK dout0_12 vdout0_12ck171 = 1.8 time = 1720
* CHECK dout0_13 vdout0_13ck171 = 0 time = 1720
* CHECK dout0_14 vdout0_14ck171 = 0 time = 1720
* CHECK dout0_15 vdout0_15ck171 = 0 time = 1720
* CHECK dout0_16 vdout0_16ck171 = 0 time = 1720
* CHECK dout0_17 vdout0_17ck171 = 1.8 time = 1720
* CHECK dout0_18 vdout0_18ck171 = 0 time = 1720
* CHECK dout0_19 vdout0_19ck171 = 1.8 time = 1720
* CHECK dout0_20 vdout0_20ck171 = 1.8 time = 1720
* CHECK dout0_21 vdout0_21ck171 = 0 time = 1720
* CHECK dout0_22 vdout0_22ck171 = 1.8 time = 1720
* CHECK dout0_23 vdout0_23ck171 = 0 time = 1720
* CHECK dout0_24 vdout0_24ck171 = 0 time = 1720
* CHECK dout0_25 vdout0_25ck171 = 1.8 time = 1720
* CHECK dout0_26 vdout0_26ck171 = 0 time = 1720
* CHECK dout0_27 vdout0_27ck171 = 1.8 time = 1720
* CHECK dout0_28 vdout0_28ck171 = 0 time = 1720
* CHECK dout0_29 vdout0_29ck171 = 0 time = 1720
* CHECK dout0_30 vdout0_30ck171 = 0 time = 1720
* CHECK dout0_31 vdout0_31ck171 = 1.8 time = 1720
* CHECK dout1_0 vdout1_0ck171 = 0 time = 1720
* CHECK dout1_1 vdout1_1ck171 = 1.8 time = 1720
* CHECK dout1_2 vdout1_2ck171 = 1.8 time = 1720
* CHECK dout1_3 vdout1_3ck171 = 0 time = 1720
* CHECK dout1_4 vdout1_4ck171 = 0 time = 1720
* CHECK dout1_5 vdout1_5ck171 = 0 time = 1720
* CHECK dout1_6 vdout1_6ck171 = 1.8 time = 1720
* CHECK dout1_7 vdout1_7ck171 = 0 time = 1720
* CHECK dout1_8 vdout1_8ck171 = 0 time = 1720
* CHECK dout1_9 vdout1_9ck171 = 1.8 time = 1720
* CHECK dout1_10 vdout1_10ck171 = 0 time = 1720
* CHECK dout1_11 vdout1_11ck171 = 1.8 time = 1720
* CHECK dout1_12 vdout1_12ck171 = 0 time = 1720
* CHECK dout1_13 vdout1_13ck171 = 1.8 time = 1720
* CHECK dout1_14 vdout1_14ck171 = 0 time = 1720
* CHECK dout1_15 vdout1_15ck171 = 1.8 time = 1720
* CHECK dout1_16 vdout1_16ck171 = 1.8 time = 1720
* CHECK dout1_17 vdout1_17ck171 = 1.8 time = 1720
* CHECK dout1_18 vdout1_18ck171 = 1.8 time = 1720
* CHECK dout1_19 vdout1_19ck171 = 0 time = 1720
* CHECK dout1_20 vdout1_20ck171 = 1.8 time = 1720
* CHECK dout1_21 vdout1_21ck171 = 1.8 time = 1720
* CHECK dout1_22 vdout1_22ck171 = 0 time = 1720
* CHECK dout1_23 vdout1_23ck171 = 1.8 time = 1720
* CHECK dout1_24 vdout1_24ck171 = 0 time = 1720
* CHECK dout1_25 vdout1_25ck171 = 1.8 time = 1720
* CHECK dout1_26 vdout1_26ck171 = 1.8 time = 1720
* CHECK dout1_27 vdout1_27ck171 = 1.8 time = 1720
* CHECK dout1_28 vdout1_28ck171 = 0 time = 1720
* CHECK dout1_29 vdout1_29ck171 = 0 time = 1720
* CHECK dout1_30 vdout1_30ck171 = 1.8 time = 1720
* CHECK dout1_31 vdout1_31ck171 = 1.8 time = 1720
* CHECK dout1_0 vdout1_0ck173 = 1.8 time = 1740
* CHECK dout1_1 vdout1_1ck173 = 0 time = 1740
* CHECK dout1_2 vdout1_2ck173 = 0 time = 1740
* CHECK dout1_3 vdout1_3ck173 = 1.8 time = 1740
* CHECK dout1_4 vdout1_4ck173 = 0 time = 1740
* CHECK dout1_5 vdout1_5ck173 = 1.8 time = 1740
* CHECK dout1_6 vdout1_6ck173 = 0 time = 1740
* CHECK dout1_7 vdout1_7ck173 = 1.8 time = 1740
* CHECK dout1_8 vdout1_8ck173 = 1.8 time = 1740
* CHECK dout1_9 vdout1_9ck173 = 0 time = 1740
* CHECK dout1_10 vdout1_10ck173 = 0 time = 1740
* CHECK dout1_11 vdout1_11ck173 = 1.8 time = 1740
* CHECK dout1_12 vdout1_12ck173 = 1.8 time = 1740
* CHECK dout1_13 vdout1_13ck173 = 1.8 time = 1740
* CHECK dout1_14 vdout1_14ck173 = 1.8 time = 1740
* CHECK dout1_15 vdout1_15ck173 = 0 time = 1740
* CHECK dout1_16 vdout1_16ck173 = 0 time = 1740
* CHECK dout1_17 vdout1_17ck173 = 0 time = 1740
* CHECK dout1_18 vdout1_18ck173 = 1.8 time = 1740
* CHECK dout1_19 vdout1_19ck173 = 1.8 time = 1740
* CHECK dout1_20 vdout1_20ck173 = 1.8 time = 1740
* CHECK dout1_21 vdout1_21ck173 = 1.8 time = 1740
* CHECK dout1_22 vdout1_22ck173 = 0 time = 1740
* CHECK dout1_23 vdout1_23ck173 = 1.8 time = 1740
* CHECK dout1_24 vdout1_24ck173 = 1.8 time = 1740
* CHECK dout1_25 vdout1_25ck173 = 1.8 time = 1740
* CHECK dout1_26 vdout1_26ck173 = 0 time = 1740
* CHECK dout1_27 vdout1_27ck173 = 1.8 time = 1740
* CHECK dout1_28 vdout1_28ck173 = 0 time = 1740
* CHECK dout1_29 vdout1_29ck173 = 0 time = 1740
* CHECK dout1_30 vdout1_30ck173 = 1.8 time = 1740
* CHECK dout1_31 vdout1_31ck173 = 0 time = 1740
* CHECK dout1_0 vdout1_0ck174 = 0 time = 1750
* CHECK dout1_1 vdout1_1ck174 = 1.8 time = 1750
* CHECK dout1_2 vdout1_2ck174 = 0 time = 1750
* CHECK dout1_3 vdout1_3ck174 = 1.8 time = 1750
* CHECK dout1_4 vdout1_4ck174 = 1.8 time = 1750
* CHECK dout1_5 vdout1_5ck174 = 1.8 time = 1750
* CHECK dout1_6 vdout1_6ck174 = 0 time = 1750
* CHECK dout1_7 vdout1_7ck174 = 0 time = 1750
* CHECK dout1_8 vdout1_8ck174 = 1.8 time = 1750
* CHECK dout1_9 vdout1_9ck174 = 1.8 time = 1750
* CHECK dout1_10 vdout1_10ck174 = 1.8 time = 1750
* CHECK dout1_11 vdout1_11ck174 = 1.8 time = 1750
* CHECK dout1_12 vdout1_12ck174 = 0 time = 1750
* CHECK dout1_13 vdout1_13ck174 = 0 time = 1750
* CHECK dout1_14 vdout1_14ck174 = 0 time = 1750
* CHECK dout1_15 vdout1_15ck174 = 1.8 time = 1750
* CHECK dout1_16 vdout1_16ck174 = 0 time = 1750
* CHECK dout1_17 vdout1_17ck174 = 1.8 time = 1750
* CHECK dout1_18 vdout1_18ck174 = 0 time = 1750
* CHECK dout1_19 vdout1_19ck174 = 0 time = 1750
* CHECK dout1_20 vdout1_20ck174 = 0 time = 1750
* CHECK dout1_21 vdout1_21ck174 = 0 time = 1750
* CHECK dout1_22 vdout1_22ck174 = 1.8 time = 1750
* CHECK dout1_23 vdout1_23ck174 = 1.8 time = 1750
* CHECK dout1_24 vdout1_24ck174 = 1.8 time = 1750
* CHECK dout1_25 vdout1_25ck174 = 0 time = 1750
* CHECK dout1_26 vdout1_26ck174 = 0 time = 1750
* CHECK dout1_27 vdout1_27ck174 = 1.8 time = 1750
* CHECK dout1_28 vdout1_28ck174 = 1.8 time = 1750
* CHECK dout1_29 vdout1_29ck174 = 0 time = 1750
* CHECK dout1_30 vdout1_30ck174 = 0 time = 1750
* CHECK dout1_31 vdout1_31ck174 = 1.8 time = 1750
* CHECK dout0_0 vdout0_0ck175 = 0 time = 1760
* CHECK dout0_1 vdout0_1ck175 = 1.8 time = 1760
* CHECK dout0_2 vdout0_2ck175 = 0 time = 1760
* CHECK dout0_3 vdout0_3ck175 = 1.8 time = 1760
* CHECK dout0_4 vdout0_4ck175 = 1.8 time = 1760
* CHECK dout0_5 vdout0_5ck175 = 1.8 time = 1760
* CHECK dout0_6 vdout0_6ck175 = 0 time = 1760
* CHECK dout0_7 vdout0_7ck175 = 0 time = 1760
* CHECK dout0_8 vdout0_8ck175 = 1.8 time = 1760
* CHECK dout0_9 vdout0_9ck175 = 1.8 time = 1760
* CHECK dout0_10 vdout0_10ck175 = 1.8 time = 1760
* CHECK dout0_11 vdout0_11ck175 = 1.8 time = 1760
* CHECK dout0_12 vdout0_12ck175 = 0 time = 1760
* CHECK dout0_13 vdout0_13ck175 = 0 time = 1760
* CHECK dout0_14 vdout0_14ck175 = 0 time = 1760
* CHECK dout0_15 vdout0_15ck175 = 1.8 time = 1760
* CHECK dout0_16 vdout0_16ck175 = 0 time = 1760
* CHECK dout0_17 vdout0_17ck175 = 1.8 time = 1760
* CHECK dout0_18 vdout0_18ck175 = 0 time = 1760
* CHECK dout0_19 vdout0_19ck175 = 0 time = 1760
* CHECK dout0_20 vdout0_20ck175 = 0 time = 1760
* CHECK dout0_21 vdout0_21ck175 = 0 time = 1760
* CHECK dout0_22 vdout0_22ck175 = 1.8 time = 1760
* CHECK dout0_23 vdout0_23ck175 = 1.8 time = 1760
* CHECK dout0_24 vdout0_24ck175 = 1.8 time = 1760
* CHECK dout0_25 vdout0_25ck175 = 0 time = 1760
* CHECK dout0_26 vdout0_26ck175 = 0 time = 1760
* CHECK dout0_27 vdout0_27ck175 = 1.8 time = 1760
* CHECK dout0_28 vdout0_28ck175 = 1.8 time = 1760
* CHECK dout0_29 vdout0_29ck175 = 0 time = 1760
* CHECK dout0_30 vdout0_30ck175 = 0 time = 1760
* CHECK dout0_31 vdout0_31ck175 = 1.8 time = 1760
* CHECK dout0_0 vdout0_0ck176 = 1.8 time = 1770
* CHECK dout0_1 vdout0_1ck176 = 0 time = 1770
* CHECK dout0_2 vdout0_2ck176 = 0 time = 1770
* CHECK dout0_3 vdout0_3ck176 = 1.8 time = 1770
* CHECK dout0_4 vdout0_4ck176 = 1.8 time = 1770
* CHECK dout0_5 vdout0_5ck176 = 0 time = 1770
* CHECK dout0_6 vdout0_6ck176 = 1.8 time = 1770
* CHECK dout0_7 vdout0_7ck176 = 1.8 time = 1770
* CHECK dout0_8 vdout0_8ck176 = 0 time = 1770
* CHECK dout0_9 vdout0_9ck176 = 1.8 time = 1770
* CHECK dout0_10 vdout0_10ck176 = 0 time = 1770
* CHECK dout0_11 vdout0_11ck176 = 0 time = 1770
* CHECK dout0_12 vdout0_12ck176 = 0 time = 1770
* CHECK dout0_13 vdout0_13ck176 = 1.8 time = 1770
* CHECK dout0_14 vdout0_14ck176 = 1.8 time = 1770
* CHECK dout0_15 vdout0_15ck176 = 1.8 time = 1770
* CHECK dout0_16 vdout0_16ck176 = 1.8 time = 1770
* CHECK dout0_17 vdout0_17ck176 = 1.8 time = 1770
* CHECK dout0_18 vdout0_18ck176 = 1.8 time = 1770
* CHECK dout0_19 vdout0_19ck176 = 1.8 time = 1770
* CHECK dout0_20 vdout0_20ck176 = 1.8 time = 1770
* CHECK dout0_21 vdout0_21ck176 = 0 time = 1770
* CHECK dout0_22 vdout0_22ck176 = 1.8 time = 1770
* CHECK dout0_23 vdout0_23ck176 = 1.8 time = 1770
* CHECK dout0_24 vdout0_24ck176 = 0 time = 1770
* CHECK dout0_25 vdout0_25ck176 = 0 time = 1770
* CHECK dout0_26 vdout0_26ck176 = 0 time = 1770
* CHECK dout0_27 vdout0_27ck176 = 0 time = 1770
* CHECK dout0_28 vdout0_28ck176 = 1.8 time = 1770
* CHECK dout0_29 vdout0_29ck176 = 0 time = 1770
* CHECK dout0_30 vdout0_30ck176 = 1.8 time = 1770
* CHECK dout0_31 vdout0_31ck176 = 1.8 time = 1770
* CHECK dout1_0 vdout1_0ck176 = 0 time = 1770
* CHECK dout1_1 vdout1_1ck176 = 1.8 time = 1770
* CHECK dout1_2 vdout1_2ck176 = 0 time = 1770
* CHECK dout1_3 vdout1_3ck176 = 1.8 time = 1770
* CHECK dout1_4 vdout1_4ck176 = 1.8 time = 1770
* CHECK dout1_5 vdout1_5ck176 = 1.8 time = 1770
* CHECK dout1_6 vdout1_6ck176 = 0 time = 1770
* CHECK dout1_7 vdout1_7ck176 = 0 time = 1770
* CHECK dout1_8 vdout1_8ck176 = 1.8 time = 1770
* CHECK dout1_9 vdout1_9ck176 = 1.8 time = 1770
* CHECK dout1_10 vdout1_10ck176 = 1.8 time = 1770
* CHECK dout1_11 vdout1_11ck176 = 1.8 time = 1770
* CHECK dout1_12 vdout1_12ck176 = 0 time = 1770
* CHECK dout1_13 vdout1_13ck176 = 0 time = 1770
* CHECK dout1_14 vdout1_14ck176 = 0 time = 1770
* CHECK dout1_15 vdout1_15ck176 = 1.8 time = 1770
* CHECK dout1_16 vdout1_16ck176 = 0 time = 1770
* CHECK dout1_17 vdout1_17ck176 = 1.8 time = 1770
* CHECK dout1_18 vdout1_18ck176 = 0 time = 1770
* CHECK dout1_19 vdout1_19ck176 = 0 time = 1770
* CHECK dout1_20 vdout1_20ck176 = 0 time = 1770
* CHECK dout1_21 vdout1_21ck176 = 0 time = 1770
* CHECK dout1_22 vdout1_22ck176 = 1.8 time = 1770
* CHECK dout1_23 vdout1_23ck176 = 1.8 time = 1770
* CHECK dout1_24 vdout1_24ck176 = 1.8 time = 1770
* CHECK dout1_25 vdout1_25ck176 = 0 time = 1770
* CHECK dout1_26 vdout1_26ck176 = 0 time = 1770
* CHECK dout1_27 vdout1_27ck176 = 1.8 time = 1770
* CHECK dout1_28 vdout1_28ck176 = 1.8 time = 1770
* CHECK dout1_29 vdout1_29ck176 = 0 time = 1770
* CHECK dout1_30 vdout1_30ck176 = 0 time = 1770
* CHECK dout1_31 vdout1_31ck176 = 1.8 time = 1770
* CHECK dout1_0 vdout1_0ck179 = 0 time = 1800
* CHECK dout1_1 vdout1_1ck179 = 1.8 time = 1800
* CHECK dout1_2 vdout1_2ck179 = 1.8 time = 1800
* CHECK dout1_3 vdout1_3ck179 = 1.8 time = 1800
* CHECK dout1_4 vdout1_4ck179 = 0 time = 1800
* CHECK dout1_5 vdout1_5ck179 = 0 time = 1800
* CHECK dout1_6 vdout1_6ck179 = 0 time = 1800
* CHECK dout1_7 vdout1_7ck179 = 1.8 time = 1800
* CHECK dout1_8 vdout1_8ck179 = 0 time = 1800
* CHECK dout1_9 vdout1_9ck179 = 0 time = 1800
* CHECK dout1_10 vdout1_10ck179 = 1.8 time = 1800
* CHECK dout1_11 vdout1_11ck179 = 1.8 time = 1800
* CHECK dout1_12 vdout1_12ck179 = 1.8 time = 1800
* CHECK dout1_13 vdout1_13ck179 = 0 time = 1800
* CHECK dout1_14 vdout1_14ck179 = 1.8 time = 1800
* CHECK dout1_15 vdout1_15ck179 = 1.8 time = 1800
* CHECK dout1_16 vdout1_16ck179 = 1.8 time = 1800
* CHECK dout1_17 vdout1_17ck179 = 0 time = 1800
* CHECK dout1_18 vdout1_18ck179 = 1.8 time = 1800
* CHECK dout1_19 vdout1_19ck179 = 0 time = 1800
* CHECK dout1_20 vdout1_20ck179 = 1.8 time = 1800
* CHECK dout1_21 vdout1_21ck179 = 1.8 time = 1800
* CHECK dout1_22 vdout1_22ck179 = 1.8 time = 1800
* CHECK dout1_23 vdout1_23ck179 = 0 time = 1800
* CHECK dout1_24 vdout1_24ck179 = 0 time = 1800
* CHECK dout1_25 vdout1_25ck179 = 1.8 time = 1800
* CHECK dout1_26 vdout1_26ck179 = 0 time = 1800
* CHECK dout1_27 vdout1_27ck179 = 0 time = 1800
* CHECK dout1_28 vdout1_28ck179 = 1.8 time = 1800
* CHECK dout1_29 vdout1_29ck179 = 1.8 time = 1800
* CHECK dout1_30 vdout1_30ck179 = 1.8 time = 1800
* CHECK dout1_31 vdout1_31ck179 = 0 time = 1800
* CHECK dout1_0 vdout1_0ck180 = 0 time = 1810
* CHECK dout1_1 vdout1_1ck180 = 1.8 time = 1810
* CHECK dout1_2 vdout1_2ck180 = 1.8 time = 1810
* CHECK dout1_3 vdout1_3ck180 = 1.8 time = 1810
* CHECK dout1_4 vdout1_4ck180 = 0 time = 1810
* CHECK dout1_5 vdout1_5ck180 = 1.8 time = 1810
* CHECK dout1_6 vdout1_6ck180 = 1.8 time = 1810
* CHECK dout1_7 vdout1_7ck180 = 1.8 time = 1810
* CHECK dout1_8 vdout1_8ck180 = 0 time = 1810
* CHECK dout1_9 vdout1_9ck180 = 0 time = 1810
* CHECK dout1_10 vdout1_10ck180 = 1.8 time = 1810
* CHECK dout1_11 vdout1_11ck180 = 1.8 time = 1810
* CHECK dout1_12 vdout1_12ck180 = 0 time = 1810
* CHECK dout1_13 vdout1_13ck180 = 1.8 time = 1810
* CHECK dout1_14 vdout1_14ck180 = 1.8 time = 1810
* CHECK dout1_15 vdout1_15ck180 = 0 time = 1810
* CHECK dout1_16 vdout1_16ck180 = 1.8 time = 1810
* CHECK dout1_17 vdout1_17ck180 = 0 time = 1810
* CHECK dout1_18 vdout1_18ck180 = 1.8 time = 1810
* CHECK dout1_19 vdout1_19ck180 = 0 time = 1810
* CHECK dout1_20 vdout1_20ck180 = 0 time = 1810
* CHECK dout1_21 vdout1_21ck180 = 1.8 time = 1810
* CHECK dout1_22 vdout1_22ck180 = 1.8 time = 1810
* CHECK dout1_23 vdout1_23ck180 = 0 time = 1810
* CHECK dout1_24 vdout1_24ck180 = 1.8 time = 1810
* CHECK dout1_25 vdout1_25ck180 = 0 time = 1810
* CHECK dout1_26 vdout1_26ck180 = 1.8 time = 1810
* CHECK dout1_27 vdout1_27ck180 = 0 time = 1810
* CHECK dout1_28 vdout1_28ck180 = 1.8 time = 1810
* CHECK dout1_29 vdout1_29ck180 = 0 time = 1810
* CHECK dout1_30 vdout1_30ck180 = 0 time = 1810
* CHECK dout1_31 vdout1_31ck180 = 0 time = 1810
* CHECK dout1_0 vdout1_0ck181 = 1.8 time = 1820
* CHECK dout1_1 vdout1_1ck181 = 1.8 time = 1820
* CHECK dout1_2 vdout1_2ck181 = 1.8 time = 1820
* CHECK dout1_3 vdout1_3ck181 = 0 time = 1820
* CHECK dout1_4 vdout1_4ck181 = 0 time = 1820
* CHECK dout1_5 vdout1_5ck181 = 1.8 time = 1820
* CHECK dout1_6 vdout1_6ck181 = 1.8 time = 1820
* CHECK dout1_7 vdout1_7ck181 = 0 time = 1820
* CHECK dout1_8 vdout1_8ck181 = 0 time = 1820
* CHECK dout1_9 vdout1_9ck181 = 0 time = 1820
* CHECK dout1_10 vdout1_10ck181 = 0 time = 1820
* CHECK dout1_11 vdout1_11ck181 = 1.8 time = 1820
* CHECK dout1_12 vdout1_12ck181 = 1.8 time = 1820
* CHECK dout1_13 vdout1_13ck181 = 1.8 time = 1820
* CHECK dout1_14 vdout1_14ck181 = 1.8 time = 1820
* CHECK dout1_15 vdout1_15ck181 = 1.8 time = 1820
* CHECK dout1_16 vdout1_16ck181 = 0 time = 1820
* CHECK dout1_17 vdout1_17ck181 = 1.8 time = 1820
* CHECK dout1_18 vdout1_18ck181 = 0 time = 1820
* CHECK dout1_19 vdout1_19ck181 = 1.8 time = 1820
* CHECK dout1_20 vdout1_20ck181 = 1.8 time = 1820
* CHECK dout1_21 vdout1_21ck181 = 0 time = 1820
* CHECK dout1_22 vdout1_22ck181 = 0 time = 1820
* CHECK dout1_23 vdout1_23ck181 = 1.8 time = 1820
* CHECK dout1_24 vdout1_24ck181 = 1.8 time = 1820
* CHECK dout1_25 vdout1_25ck181 = 1.8 time = 1820
* CHECK dout1_26 vdout1_26ck181 = 0 time = 1820
* CHECK dout1_27 vdout1_27ck181 = 1.8 time = 1820
* CHECK dout1_28 vdout1_28ck181 = 0 time = 1820
* CHECK dout1_29 vdout1_29ck181 = 1.8 time = 1820
* CHECK dout1_30 vdout1_30ck181 = 1.8 time = 1820
* CHECK dout1_31 vdout1_31ck181 = 0 time = 1820
* CHECK dout0_0 vdout0_0ck182 = 0 time = 1830
* CHECK dout0_1 vdout0_1ck182 = 1.8 time = 1830
* CHECK dout0_2 vdout0_2ck182 = 1.8 time = 1830
* CHECK dout0_3 vdout0_3ck182 = 1.8 time = 1830
* CHECK dout0_4 vdout0_4ck182 = 0 time = 1830
* CHECK dout0_5 vdout0_5ck182 = 0 time = 1830
* CHECK dout0_6 vdout0_6ck182 = 0 time = 1830
* CHECK dout0_7 vdout0_7ck182 = 1.8 time = 1830
* CHECK dout0_8 vdout0_8ck182 = 0 time = 1830
* CHECK dout0_9 vdout0_9ck182 = 0 time = 1830
* CHECK dout0_10 vdout0_10ck182 = 1.8 time = 1830
* CHECK dout0_11 vdout0_11ck182 = 1.8 time = 1830
* CHECK dout0_12 vdout0_12ck182 = 1.8 time = 1830
* CHECK dout0_13 vdout0_13ck182 = 0 time = 1830
* CHECK dout0_14 vdout0_14ck182 = 1.8 time = 1830
* CHECK dout0_15 vdout0_15ck182 = 1.8 time = 1830
* CHECK dout0_16 vdout0_16ck182 = 1.8 time = 1830
* CHECK dout0_17 vdout0_17ck182 = 0 time = 1830
* CHECK dout0_18 vdout0_18ck182 = 1.8 time = 1830
* CHECK dout0_19 vdout0_19ck182 = 0 time = 1830
* CHECK dout0_20 vdout0_20ck182 = 1.8 time = 1830
* CHECK dout0_21 vdout0_21ck182 = 1.8 time = 1830
* CHECK dout0_22 vdout0_22ck182 = 1.8 time = 1830
* CHECK dout0_23 vdout0_23ck182 = 0 time = 1830
* CHECK dout0_24 vdout0_24ck182 = 0 time = 1830
* CHECK dout0_25 vdout0_25ck182 = 1.8 time = 1830
* CHECK dout0_26 vdout0_26ck182 = 0 time = 1830
* CHECK dout0_27 vdout0_27ck182 = 0 time = 1830
* CHECK dout0_28 vdout0_28ck182 = 1.8 time = 1830
* CHECK dout0_29 vdout0_29ck182 = 1.8 time = 1830
* CHECK dout0_30 vdout0_30ck182 = 1.8 time = 1830
* CHECK dout0_31 vdout0_31ck182 = 0 time = 1830
* CHECK dout1_0 vdout1_0ck182 = 0 time = 1830
* CHECK dout1_1 vdout1_1ck182 = 1.8 time = 1830
* CHECK dout1_2 vdout1_2ck182 = 0 time = 1830
* CHECK dout1_3 vdout1_3ck182 = 1.8 time = 1830
* CHECK dout1_4 vdout1_4ck182 = 1.8 time = 1830
* CHECK dout1_5 vdout1_5ck182 = 1.8 time = 1830
* CHECK dout1_6 vdout1_6ck182 = 0 time = 1830
* CHECK dout1_7 vdout1_7ck182 = 0 time = 1830
* CHECK dout1_8 vdout1_8ck182 = 1.8 time = 1830
* CHECK dout1_9 vdout1_9ck182 = 1.8 time = 1830
* CHECK dout1_10 vdout1_10ck182 = 1.8 time = 1830
* CHECK dout1_11 vdout1_11ck182 = 1.8 time = 1830
* CHECK dout1_12 vdout1_12ck182 = 0 time = 1830
* CHECK dout1_13 vdout1_13ck182 = 0 time = 1830
* CHECK dout1_14 vdout1_14ck182 = 0 time = 1830
* CHECK dout1_15 vdout1_15ck182 = 1.8 time = 1830
* CHECK dout1_16 vdout1_16ck182 = 0 time = 1830
* CHECK dout1_17 vdout1_17ck182 = 1.8 time = 1830
* CHECK dout1_18 vdout1_18ck182 = 0 time = 1830
* CHECK dout1_19 vdout1_19ck182 = 0 time = 1830
* CHECK dout1_20 vdout1_20ck182 = 0 time = 1830
* CHECK dout1_21 vdout1_21ck182 = 0 time = 1830
* CHECK dout1_22 vdout1_22ck182 = 1.8 time = 1830
* CHECK dout1_23 vdout1_23ck182 = 1.8 time = 1830
* CHECK dout1_24 vdout1_24ck182 = 1.8 time = 1830
* CHECK dout1_25 vdout1_25ck182 = 0 time = 1830
* CHECK dout1_26 vdout1_26ck182 = 0 time = 1830
* CHECK dout1_27 vdout1_27ck182 = 1.8 time = 1830
* CHECK dout1_28 vdout1_28ck182 = 1.8 time = 1830
* CHECK dout1_29 vdout1_29ck182 = 0 time = 1830
* CHECK dout1_30 vdout1_30ck182 = 0 time = 1830
* CHECK dout1_31 vdout1_31ck182 = 1.8 time = 1830
* CHECK dout0_0 vdout0_0ck183 = 0 time = 1840
* CHECK dout0_1 vdout0_1ck183 = 0 time = 1840
* CHECK dout0_2 vdout0_2ck183 = 1.8 time = 1840
* CHECK dout0_3 vdout0_3ck183 = 0 time = 1840
* CHECK dout0_4 vdout0_4ck183 = 0 time = 1840
* CHECK dout0_5 vdout0_5ck183 = 0 time = 1840
* CHECK dout0_6 vdout0_6ck183 = 1.8 time = 1840
* CHECK dout0_7 vdout0_7ck183 = 1.8 time = 1840
* CHECK dout0_8 vdout0_8ck183 = 1.8 time = 1840
* CHECK dout0_9 vdout0_9ck183 = 1.8 time = 1840
* CHECK dout0_10 vdout0_10ck183 = 0 time = 1840
* CHECK dout0_11 vdout0_11ck183 = 0 time = 1840
* CHECK dout0_12 vdout0_12ck183 = 1.8 time = 1840
* CHECK dout0_13 vdout0_13ck183 = 0 time = 1840
* CHECK dout0_14 vdout0_14ck183 = 0 time = 1840
* CHECK dout0_15 vdout0_15ck183 = 0 time = 1840
* CHECK dout0_16 vdout0_16ck183 = 0 time = 1840
* CHECK dout0_17 vdout0_17ck183 = 1.8 time = 1840
* CHECK dout0_18 vdout0_18ck183 = 0 time = 1840
* CHECK dout0_19 vdout0_19ck183 = 1.8 time = 1840
* CHECK dout0_20 vdout0_20ck183 = 1.8 time = 1840
* CHECK dout0_21 vdout0_21ck183 = 0 time = 1840
* CHECK dout0_22 vdout0_22ck183 = 1.8 time = 1840
* CHECK dout0_23 vdout0_23ck183 = 0 time = 1840
* CHECK dout0_24 vdout0_24ck183 = 0 time = 1840
* CHECK dout0_25 vdout0_25ck183 = 1.8 time = 1840
* CHECK dout0_26 vdout0_26ck183 = 0 time = 1840
* CHECK dout0_27 vdout0_27ck183 = 1.8 time = 1840
* CHECK dout0_28 vdout0_28ck183 = 0 time = 1840
* CHECK dout0_29 vdout0_29ck183 = 0 time = 1840
* CHECK dout0_30 vdout0_30ck183 = 0 time = 1840
* CHECK dout0_31 vdout0_31ck183 = 1.8 time = 1840
* CHECK dout0_0 vdout0_0ck184 = 0 time = 1850
* CHECK dout0_1 vdout0_1ck184 = 1.8 time = 1850
* CHECK dout0_2 vdout0_2ck184 = 0 time = 1850
* CHECK dout0_3 vdout0_3ck184 = 1.8 time = 1850
* CHECK dout0_4 vdout0_4ck184 = 0 time = 1850
* CHECK dout0_5 vdout0_5ck184 = 1.8 time = 1850
* CHECK dout0_6 vdout0_6ck184 = 0 time = 1850
* CHECK dout0_7 vdout0_7ck184 = 1.8 time = 1850
* CHECK dout0_8 vdout0_8ck184 = 0 time = 1850
* CHECK dout0_9 vdout0_9ck184 = 1.8 time = 1850
* CHECK dout0_10 vdout0_10ck184 = 0 time = 1850
* CHECK dout0_11 vdout0_11ck184 = 1.8 time = 1850
* CHECK dout0_12 vdout0_12ck184 = 0 time = 1850
* CHECK dout0_13 vdout0_13ck184 = 0 time = 1850
* CHECK dout0_14 vdout0_14ck184 = 1.8 time = 1850
* CHECK dout0_15 vdout0_15ck184 = 0 time = 1850
* CHECK dout0_16 vdout0_16ck184 = 1.8 time = 1850
* CHECK dout0_17 vdout0_17ck184 = 0 time = 1850
* CHECK dout0_18 vdout0_18ck184 = 0 time = 1850
* CHECK dout0_19 vdout0_19ck184 = 1.8 time = 1850
* CHECK dout0_20 vdout0_20ck184 = 0 time = 1850
* CHECK dout0_21 vdout0_21ck184 = 0 time = 1850
* CHECK dout0_22 vdout0_22ck184 = 1.8 time = 1850
* CHECK dout0_23 vdout0_23ck184 = 0 time = 1850
* CHECK dout0_24 vdout0_24ck184 = 1.8 time = 1850
* CHECK dout0_25 vdout0_25ck184 = 1.8 time = 1850
* CHECK dout0_26 vdout0_26ck184 = 1.8 time = 1850
* CHECK dout0_27 vdout0_27ck184 = 1.8 time = 1850
* CHECK dout0_28 vdout0_28ck184 = 0 time = 1850
* CHECK dout0_29 vdout0_29ck184 = 1.8 time = 1850
* CHECK dout0_30 vdout0_30ck184 = 1.8 time = 1850
* CHECK dout0_31 vdout0_31ck184 = 1.8 time = 1850
* CHECK dout1_0 vdout1_0ck184 = 1.8 time = 1850
* CHECK dout1_1 vdout1_1ck184 = 0 time = 1850
* CHECK dout1_2 vdout1_2ck184 = 0 time = 1850
* CHECK dout1_3 vdout1_3ck184 = 1.8 time = 1850
* CHECK dout1_4 vdout1_4ck184 = 0 time = 1850
* CHECK dout1_5 vdout1_5ck184 = 1.8 time = 1850
* CHECK dout1_6 vdout1_6ck184 = 1.8 time = 1850
* CHECK dout1_7 vdout1_7ck184 = 0 time = 1850
* CHECK dout1_8 vdout1_8ck184 = 0 time = 1850
* CHECK dout1_9 vdout1_9ck184 = 1.8 time = 1850
* CHECK dout1_10 vdout1_10ck184 = 1.8 time = 1850
* CHECK dout1_11 vdout1_11ck184 = 1.8 time = 1850
* CHECK dout1_12 vdout1_12ck184 = 0 time = 1850
* CHECK dout1_13 vdout1_13ck184 = 0 time = 1850
* CHECK dout1_14 vdout1_14ck184 = 0 time = 1850
* CHECK dout1_15 vdout1_15ck184 = 0 time = 1850
* CHECK dout1_16 vdout1_16ck184 = 0 time = 1850
* CHECK dout1_17 vdout1_17ck184 = 1.8 time = 1850
* CHECK dout1_18 vdout1_18ck184 = 0 time = 1850
* CHECK dout1_19 vdout1_19ck184 = 1.8 time = 1850
* CHECK dout1_20 vdout1_20ck184 = 0 time = 1850
* CHECK dout1_21 vdout1_21ck184 = 0 time = 1850
* CHECK dout1_22 vdout1_22ck184 = 1.8 time = 1850
* CHECK dout1_23 vdout1_23ck184 = 0 time = 1850
* CHECK dout1_24 vdout1_24ck184 = 0 time = 1850
* CHECK dout1_25 vdout1_25ck184 = 1.8 time = 1850
* CHECK dout1_26 vdout1_26ck184 = 0 time = 1850
* CHECK dout1_27 vdout1_27ck184 = 0 time = 1850
* CHECK dout1_28 vdout1_28ck184 = 0 time = 1850
* CHECK dout1_29 vdout1_29ck184 = 0 time = 1850
* CHECK dout1_30 vdout1_30ck184 = 0 time = 1850
* CHECK dout1_31 vdout1_31ck184 = 1.8 time = 1850
* CHECK dout0_0 vdout0_0ck185 = 0 time = 1860
* CHECK dout0_1 vdout0_1ck185 = 1.8 time = 1860
* CHECK dout0_2 vdout0_2ck185 = 0 time = 1860
* CHECK dout0_3 vdout0_3ck185 = 1.8 time = 1860
* CHECK dout0_4 vdout0_4ck185 = 0 time = 1860
* CHECK dout0_5 vdout0_5ck185 = 1.8 time = 1860
* CHECK dout0_6 vdout0_6ck185 = 0 time = 1860
* CHECK dout0_7 vdout0_7ck185 = 1.8 time = 1860
* CHECK dout0_8 vdout0_8ck185 = 0 time = 1860
* CHECK dout0_9 vdout0_9ck185 = 1.8 time = 1860
* CHECK dout0_10 vdout0_10ck185 = 0 time = 1860
* CHECK dout0_11 vdout0_11ck185 = 1.8 time = 1860
* CHECK dout0_12 vdout0_12ck185 = 0 time = 1860
* CHECK dout0_13 vdout0_13ck185 = 0 time = 1860
* CHECK dout0_14 vdout0_14ck185 = 1.8 time = 1860
* CHECK dout0_15 vdout0_15ck185 = 0 time = 1860
* CHECK dout0_16 vdout0_16ck185 = 1.8 time = 1860
* CHECK dout0_17 vdout0_17ck185 = 0 time = 1860
* CHECK dout0_18 vdout0_18ck185 = 0 time = 1860
* CHECK dout0_19 vdout0_19ck185 = 1.8 time = 1860
* CHECK dout0_20 vdout0_20ck185 = 0 time = 1860
* CHECK dout0_21 vdout0_21ck185 = 0 time = 1860
* CHECK dout0_22 vdout0_22ck185 = 1.8 time = 1860
* CHECK dout0_23 vdout0_23ck185 = 0 time = 1860
* CHECK dout0_24 vdout0_24ck185 = 1.8 time = 1860
* CHECK dout0_25 vdout0_25ck185 = 1.8 time = 1860
* CHECK dout0_26 vdout0_26ck185 = 1.8 time = 1860
* CHECK dout0_27 vdout0_27ck185 = 1.8 time = 1860
* CHECK dout0_28 vdout0_28ck185 = 0 time = 1860
* CHECK dout0_29 vdout0_29ck185 = 1.8 time = 1860
* CHECK dout0_30 vdout0_30ck185 = 1.8 time = 1860
* CHECK dout0_31 vdout0_31ck185 = 1.8 time = 1860
* CHECK dout1_0 vdout1_0ck185 = 1.8 time = 1860
* CHECK dout1_1 vdout1_1ck185 = 1.8 time = 1860
* CHECK dout1_2 vdout1_2ck185 = 1.8 time = 1860
* CHECK dout1_3 vdout1_3ck185 = 0 time = 1860
* CHECK dout1_4 vdout1_4ck185 = 0 time = 1860
* CHECK dout1_5 vdout1_5ck185 = 1.8 time = 1860
* CHECK dout1_6 vdout1_6ck185 = 1.8 time = 1860
* CHECK dout1_7 vdout1_7ck185 = 0 time = 1860
* CHECK dout1_8 vdout1_8ck185 = 0 time = 1860
* CHECK dout1_9 vdout1_9ck185 = 0 time = 1860
* CHECK dout1_10 vdout1_10ck185 = 0 time = 1860
* CHECK dout1_11 vdout1_11ck185 = 1.8 time = 1860
* CHECK dout1_12 vdout1_12ck185 = 1.8 time = 1860
* CHECK dout1_13 vdout1_13ck185 = 1.8 time = 1860
* CHECK dout1_14 vdout1_14ck185 = 1.8 time = 1860
* CHECK dout1_15 vdout1_15ck185 = 1.8 time = 1860
* CHECK dout1_16 vdout1_16ck185 = 0 time = 1860
* CHECK dout1_17 vdout1_17ck185 = 1.8 time = 1860
* CHECK dout1_18 vdout1_18ck185 = 0 time = 1860
* CHECK dout1_19 vdout1_19ck185 = 1.8 time = 1860
* CHECK dout1_20 vdout1_20ck185 = 1.8 time = 1860
* CHECK dout1_21 vdout1_21ck185 = 0 time = 1860
* CHECK dout1_22 vdout1_22ck185 = 0 time = 1860
* CHECK dout1_23 vdout1_23ck185 = 1.8 time = 1860
* CHECK dout1_24 vdout1_24ck185 = 1.8 time = 1860
* CHECK dout1_25 vdout1_25ck185 = 1.8 time = 1860
* CHECK dout1_26 vdout1_26ck185 = 0 time = 1860
* CHECK dout1_27 vdout1_27ck185 = 1.8 time = 1860
* CHECK dout1_28 vdout1_28ck185 = 0 time = 1860
* CHECK dout1_29 vdout1_29ck185 = 1.8 time = 1860
* CHECK dout1_30 vdout1_30ck185 = 1.8 time = 1860
* CHECK dout1_31 vdout1_31ck185 = 0 time = 1860
* CHECK dout0_0 vdout0_0ck186 = 0 time = 1870
* CHECK dout0_1 vdout0_1ck186 = 1.8 time = 1870
* CHECK dout0_2 vdout0_2ck186 = 0 time = 1870
* CHECK dout0_3 vdout0_3ck186 = 1.8 time = 1870
* CHECK dout0_4 vdout0_4ck186 = 1.8 time = 1870
* CHECK dout0_5 vdout0_5ck186 = 1.8 time = 1870
* CHECK dout0_6 vdout0_6ck186 = 0 time = 1870
* CHECK dout0_7 vdout0_7ck186 = 0 time = 1870
* CHECK dout0_8 vdout0_8ck186 = 1.8 time = 1870
* CHECK dout0_9 vdout0_9ck186 = 1.8 time = 1870
* CHECK dout0_10 vdout0_10ck186 = 1.8 time = 1870
* CHECK dout0_11 vdout0_11ck186 = 1.8 time = 1870
* CHECK dout0_12 vdout0_12ck186 = 0 time = 1870
* CHECK dout0_13 vdout0_13ck186 = 0 time = 1870
* CHECK dout0_14 vdout0_14ck186 = 0 time = 1870
* CHECK dout0_15 vdout0_15ck186 = 1.8 time = 1870
* CHECK dout0_16 vdout0_16ck186 = 0 time = 1870
* CHECK dout0_17 vdout0_17ck186 = 1.8 time = 1870
* CHECK dout0_18 vdout0_18ck186 = 0 time = 1870
* CHECK dout0_19 vdout0_19ck186 = 0 time = 1870
* CHECK dout0_20 vdout0_20ck186 = 0 time = 1870
* CHECK dout0_21 vdout0_21ck186 = 0 time = 1870
* CHECK dout0_22 vdout0_22ck186 = 1.8 time = 1870
* CHECK dout0_23 vdout0_23ck186 = 1.8 time = 1870
* CHECK dout0_24 vdout0_24ck186 = 1.8 time = 1870
* CHECK dout0_25 vdout0_25ck186 = 0 time = 1870
* CHECK dout0_26 vdout0_26ck186 = 0 time = 1870
* CHECK dout0_27 vdout0_27ck186 = 1.8 time = 1870
* CHECK dout0_28 vdout0_28ck186 = 1.8 time = 1870
* CHECK dout0_29 vdout0_29ck186 = 0 time = 1870
* CHECK dout0_30 vdout0_30ck186 = 0 time = 1870
* CHECK dout0_31 vdout0_31ck186 = 1.8 time = 1870
* CHECK dout1_0 vdout1_0ck187 = 0 time = 1880
* CHECK dout1_1 vdout1_1ck187 = 1.8 time = 1880
* CHECK dout1_2 vdout1_2ck187 = 1.8 time = 1880
* CHECK dout1_3 vdout1_3ck187 = 1.8 time = 1880
* CHECK dout1_4 vdout1_4ck187 = 0 time = 1880
* CHECK dout1_5 vdout1_5ck187 = 0 time = 1880
* CHECK dout1_6 vdout1_6ck187 = 0 time = 1880
* CHECK dout1_7 vdout1_7ck187 = 1.8 time = 1880
* CHECK dout1_8 vdout1_8ck187 = 0 time = 1880
* CHECK dout1_9 vdout1_9ck187 = 0 time = 1880
* CHECK dout1_10 vdout1_10ck187 = 1.8 time = 1880
* CHECK dout1_11 vdout1_11ck187 = 1.8 time = 1880
* CHECK dout1_12 vdout1_12ck187 = 1.8 time = 1880
* CHECK dout1_13 vdout1_13ck187 = 0 time = 1880
* CHECK dout1_14 vdout1_14ck187 = 1.8 time = 1880
* CHECK dout1_15 vdout1_15ck187 = 1.8 time = 1880
* CHECK dout1_16 vdout1_16ck187 = 1.8 time = 1880
* CHECK dout1_17 vdout1_17ck187 = 0 time = 1880
* CHECK dout1_18 vdout1_18ck187 = 1.8 time = 1880
* CHECK dout1_19 vdout1_19ck187 = 0 time = 1880
* CHECK dout1_20 vdout1_20ck187 = 1.8 time = 1880
* CHECK dout1_21 vdout1_21ck187 = 1.8 time = 1880
* CHECK dout1_22 vdout1_22ck187 = 1.8 time = 1880
* CHECK dout1_23 vdout1_23ck187 = 0 time = 1880
* CHECK dout1_24 vdout1_24ck187 = 0 time = 1880
* CHECK dout1_25 vdout1_25ck187 = 1.8 time = 1880
* CHECK dout1_26 vdout1_26ck187 = 0 time = 1880
* CHECK dout1_27 vdout1_27ck187 = 0 time = 1880
* CHECK dout1_28 vdout1_28ck187 = 1.8 time = 1880
* CHECK dout1_29 vdout1_29ck187 = 1.8 time = 1880
* CHECK dout1_30 vdout1_30ck187 = 1.8 time = 1880
* CHECK dout1_31 vdout1_31ck187 = 0 time = 1880
* CHECK dout1_0 vdout1_0ck188 = 0 time = 1890
* CHECK dout1_1 vdout1_1ck188 = 1.8 time = 1890
* CHECK dout1_2 vdout1_2ck188 = 0 time = 1890
* CHECK dout1_3 vdout1_3ck188 = 1.8 time = 1890
* CHECK dout1_4 vdout1_4ck188 = 0 time = 1890
* CHECK dout1_5 vdout1_5ck188 = 1.8 time = 1890
* CHECK dout1_6 vdout1_6ck188 = 0 time = 1890
* CHECK dout1_7 vdout1_7ck188 = 1.8 time = 1890
* CHECK dout1_8 vdout1_8ck188 = 0 time = 1890
* CHECK dout1_9 vdout1_9ck188 = 1.8 time = 1890
* CHECK dout1_10 vdout1_10ck188 = 0 time = 1890
* CHECK dout1_11 vdout1_11ck188 = 1.8 time = 1890
* CHECK dout1_12 vdout1_12ck188 = 0 time = 1890
* CHECK dout1_13 vdout1_13ck188 = 0 time = 1890
* CHECK dout1_14 vdout1_14ck188 = 1.8 time = 1890
* CHECK dout1_15 vdout1_15ck188 = 0 time = 1890
* CHECK dout1_16 vdout1_16ck188 = 1.8 time = 1890
* CHECK dout1_17 vdout1_17ck188 = 0 time = 1890
* CHECK dout1_18 vdout1_18ck188 = 0 time = 1890
* CHECK dout1_19 vdout1_19ck188 = 1.8 time = 1890
* CHECK dout1_20 vdout1_20ck188 = 0 time = 1890
* CHECK dout1_21 vdout1_21ck188 = 0 time = 1890
* CHECK dout1_22 vdout1_22ck188 = 1.8 time = 1890
* CHECK dout1_23 vdout1_23ck188 = 0 time = 1890
* CHECK dout1_24 vdout1_24ck188 = 1.8 time = 1890
* CHECK dout1_25 vdout1_25ck188 = 1.8 time = 1890
* CHECK dout1_26 vdout1_26ck188 = 1.8 time = 1890
* CHECK dout1_27 vdout1_27ck188 = 1.8 time = 1890
* CHECK dout1_28 vdout1_28ck188 = 0 time = 1890
* CHECK dout1_29 vdout1_29ck188 = 1.8 time = 1890
* CHECK dout1_30 vdout1_30ck188 = 1.8 time = 1890
* CHECK dout1_31 vdout1_31ck188 = 1.8 time = 1890
* CHECK dout0_0 vdout0_0ck189 = 0 time = 1900
* CHECK dout0_1 vdout0_1ck189 = 1.8 time = 1900
* CHECK dout0_2 vdout0_2ck189 = 0 time = 1900
* CHECK dout0_3 vdout0_3ck189 = 1.8 time = 1900
* CHECK dout0_4 vdout0_4ck189 = 0 time = 1900
* CHECK dout0_5 vdout0_5ck189 = 1.8 time = 1900
* CHECK dout0_6 vdout0_6ck189 = 0 time = 1900
* CHECK dout0_7 vdout0_7ck189 = 1.8 time = 1900
* CHECK dout0_8 vdout0_8ck189 = 0 time = 1900
* CHECK dout0_9 vdout0_9ck189 = 1.8 time = 1900
* CHECK dout0_10 vdout0_10ck189 = 0 time = 1900
* CHECK dout0_11 vdout0_11ck189 = 1.8 time = 1900
* CHECK dout0_12 vdout0_12ck189 = 0 time = 1900
* CHECK dout0_13 vdout0_13ck189 = 0 time = 1900
* CHECK dout0_14 vdout0_14ck189 = 1.8 time = 1900
* CHECK dout0_15 vdout0_15ck189 = 0 time = 1900
* CHECK dout0_16 vdout0_16ck189 = 1.8 time = 1900
* CHECK dout0_17 vdout0_17ck189 = 0 time = 1900
* CHECK dout0_18 vdout0_18ck189 = 0 time = 1900
* CHECK dout0_19 vdout0_19ck189 = 1.8 time = 1900
* CHECK dout0_20 vdout0_20ck189 = 0 time = 1900
* CHECK dout0_21 vdout0_21ck189 = 0 time = 1900
* CHECK dout0_22 vdout0_22ck189 = 1.8 time = 1900
* CHECK dout0_23 vdout0_23ck189 = 0 time = 1900
* CHECK dout0_24 vdout0_24ck189 = 1.8 time = 1900
* CHECK dout0_25 vdout0_25ck189 = 1.8 time = 1900
* CHECK dout0_26 vdout0_26ck189 = 1.8 time = 1900
* CHECK dout0_27 vdout0_27ck189 = 1.8 time = 1900
* CHECK dout0_28 vdout0_28ck189 = 0 time = 1900
* CHECK dout0_29 vdout0_29ck189 = 1.8 time = 1900
* CHECK dout0_30 vdout0_30ck189 = 1.8 time = 1900
* CHECK dout0_31 vdout0_31ck189 = 1.8 time = 1900
* CHECK dout1_0 vdout1_0ck190 = 1.8 time = 1910
* CHECK dout1_1 vdout1_1ck190 = 0 time = 1910
* CHECK dout1_2 vdout1_2ck190 = 0 time = 1910
* CHECK dout1_3 vdout1_3ck190 = 1.8 time = 1910
* CHECK dout1_4 vdout1_4ck190 = 1.8 time = 1910
* CHECK dout1_5 vdout1_5ck190 = 0 time = 1910
* CHECK dout1_6 vdout1_6ck190 = 1.8 time = 1910
* CHECK dout1_7 vdout1_7ck190 = 1.8 time = 1910
* CHECK dout1_8 vdout1_8ck190 = 0 time = 1910
* CHECK dout1_9 vdout1_9ck190 = 1.8 time = 1910
* CHECK dout1_10 vdout1_10ck190 = 0 time = 1910
* CHECK dout1_11 vdout1_11ck190 = 0 time = 1910
* CHECK dout1_12 vdout1_12ck190 = 0 time = 1910
* CHECK dout1_13 vdout1_13ck190 = 1.8 time = 1910
* CHECK dout1_14 vdout1_14ck190 = 1.8 time = 1910
* CHECK dout1_15 vdout1_15ck190 = 1.8 time = 1910
* CHECK dout1_16 vdout1_16ck190 = 1.8 time = 1910
* CHECK dout1_17 vdout1_17ck190 = 1.8 time = 1910
* CHECK dout1_18 vdout1_18ck190 = 1.8 time = 1910
* CHECK dout1_19 vdout1_19ck190 = 1.8 time = 1910
* CHECK dout1_20 vdout1_20ck190 = 1.8 time = 1910
* CHECK dout1_21 vdout1_21ck190 = 0 time = 1910
* CHECK dout1_22 vdout1_22ck190 = 1.8 time = 1910
* CHECK dout1_23 vdout1_23ck190 = 1.8 time = 1910
* CHECK dout1_24 vdout1_24ck190 = 0 time = 1910
* CHECK dout1_25 vdout1_25ck190 = 0 time = 1910
* CHECK dout1_26 vdout1_26ck190 = 0 time = 1910
* CHECK dout1_27 vdout1_27ck190 = 0 time = 1910
* CHECK dout1_28 vdout1_28ck190 = 1.8 time = 1910
* CHECK dout1_29 vdout1_29ck190 = 0 time = 1910
* CHECK dout1_30 vdout1_30ck190 = 1.8 time = 1910
* CHECK dout1_31 vdout1_31ck190 = 1.8 time = 1910
* CHECK dout1_0 vdout1_0ck192 = 1.8 time = 1930
* CHECK dout1_1 vdout1_1ck192 = 0 time = 1930
* CHECK dout1_2 vdout1_2ck192 = 0 time = 1930
* CHECK dout1_3 vdout1_3ck192 = 1.8 time = 1930
* CHECK dout1_4 vdout1_4ck192 = 1.8 time = 1930
* CHECK dout1_5 vdout1_5ck192 = 0 time = 1930
* CHECK dout1_6 vdout1_6ck192 = 1.8 time = 1930
* CHECK dout1_7 vdout1_7ck192 = 1.8 time = 1930
* CHECK dout1_8 vdout1_8ck192 = 0 time = 1930
* CHECK dout1_9 vdout1_9ck192 = 1.8 time = 1930
* CHECK dout1_10 vdout1_10ck192 = 0 time = 1930
* CHECK dout1_11 vdout1_11ck192 = 0 time = 1930
* CHECK dout1_12 vdout1_12ck192 = 0 time = 1930
* CHECK dout1_13 vdout1_13ck192 = 1.8 time = 1930
* CHECK dout1_14 vdout1_14ck192 = 1.8 time = 1930
* CHECK dout1_15 vdout1_15ck192 = 1.8 time = 1930
* CHECK dout1_16 vdout1_16ck192 = 1.8 time = 1930
* CHECK dout1_17 vdout1_17ck192 = 1.8 time = 1930
* CHECK dout1_18 vdout1_18ck192 = 1.8 time = 1930
* CHECK dout1_19 vdout1_19ck192 = 1.8 time = 1930
* CHECK dout1_20 vdout1_20ck192 = 1.8 time = 1930
* CHECK dout1_21 vdout1_21ck192 = 0 time = 1930
* CHECK dout1_22 vdout1_22ck192 = 1.8 time = 1930
* CHECK dout1_23 vdout1_23ck192 = 1.8 time = 1930
* CHECK dout1_24 vdout1_24ck192 = 0 time = 1930
* CHECK dout1_25 vdout1_25ck192 = 0 time = 1930
* CHECK dout1_26 vdout1_26ck192 = 0 time = 1930
* CHECK dout1_27 vdout1_27ck192 = 0 time = 1930
* CHECK dout1_28 vdout1_28ck192 = 1.8 time = 1930
* CHECK dout1_29 vdout1_29ck192 = 0 time = 1930
* CHECK dout1_30 vdout1_30ck192 = 1.8 time = 1930
* CHECK dout1_31 vdout1_31ck192 = 1.8 time = 1930
* CHECK dout1_0 vdout1_0ck193 = 0 time = 1940
* CHECK dout1_1 vdout1_1ck193 = 1.8 time = 1940
* CHECK dout1_2 vdout1_2ck193 = 0 time = 1940
* CHECK dout1_3 vdout1_3ck193 = 1.8 time = 1940
* CHECK dout1_4 vdout1_4ck193 = 1.8 time = 1940
* CHECK dout1_5 vdout1_5ck193 = 1.8 time = 1940
* CHECK dout1_6 vdout1_6ck193 = 0 time = 1940
* CHECK dout1_7 vdout1_7ck193 = 0 time = 1940
* CHECK dout1_8 vdout1_8ck193 = 1.8 time = 1940
* CHECK dout1_9 vdout1_9ck193 = 1.8 time = 1940
* CHECK dout1_10 vdout1_10ck193 = 1.8 time = 1940
* CHECK dout1_11 vdout1_11ck193 = 1.8 time = 1940
* CHECK dout1_12 vdout1_12ck193 = 0 time = 1940
* CHECK dout1_13 vdout1_13ck193 = 0 time = 1940
* CHECK dout1_14 vdout1_14ck193 = 0 time = 1940
* CHECK dout1_15 vdout1_15ck193 = 1.8 time = 1940
* CHECK dout1_16 vdout1_16ck193 = 0 time = 1940
* CHECK dout1_17 vdout1_17ck193 = 1.8 time = 1940
* CHECK dout1_18 vdout1_18ck193 = 0 time = 1940
* CHECK dout1_19 vdout1_19ck193 = 0 time = 1940
* CHECK dout1_20 vdout1_20ck193 = 0 time = 1940
* CHECK dout1_21 vdout1_21ck193 = 0 time = 1940
* CHECK dout1_22 vdout1_22ck193 = 1.8 time = 1940
* CHECK dout1_23 vdout1_23ck193 = 1.8 time = 1940
* CHECK dout1_24 vdout1_24ck193 = 1.8 time = 1940
* CHECK dout1_25 vdout1_25ck193 = 0 time = 1940
* CHECK dout1_26 vdout1_26ck193 = 0 time = 1940
* CHECK dout1_27 vdout1_27ck193 = 1.8 time = 1940
* CHECK dout1_28 vdout1_28ck193 = 1.8 time = 1940
* CHECK dout1_29 vdout1_29ck193 = 0 time = 1940
* CHECK dout1_30 vdout1_30ck193 = 0 time = 1940
* CHECK dout1_31 vdout1_31ck193 = 1.8 time = 1940
* CHECK dout0_0 vdout0_0ck194 = 1.8 time = 1950
* CHECK dout0_1 vdout0_1ck194 = 0 time = 1950
* CHECK dout0_2 vdout0_2ck194 = 0 time = 1950
* CHECK dout0_3 vdout0_3ck194 = 1.8 time = 1950
* CHECK dout0_4 vdout0_4ck194 = 1.8 time = 1950
* CHECK dout0_5 vdout0_5ck194 = 0 time = 1950
* CHECK dout0_6 vdout0_6ck194 = 1.8 time = 1950
* CHECK dout0_7 vdout0_7ck194 = 1.8 time = 1950
* CHECK dout0_8 vdout0_8ck194 = 0 time = 1950
* CHECK dout0_9 vdout0_9ck194 = 1.8 time = 1950
* CHECK dout0_10 vdout0_10ck194 = 0 time = 1950
* CHECK dout0_11 vdout0_11ck194 = 0 time = 1950
* CHECK dout0_12 vdout0_12ck194 = 0 time = 1950
* CHECK dout0_13 vdout0_13ck194 = 1.8 time = 1950
* CHECK dout0_14 vdout0_14ck194 = 1.8 time = 1950
* CHECK dout0_15 vdout0_15ck194 = 1.8 time = 1950
* CHECK dout0_16 vdout0_16ck194 = 1.8 time = 1950
* CHECK dout0_17 vdout0_17ck194 = 1.8 time = 1950
* CHECK dout0_18 vdout0_18ck194 = 1.8 time = 1950
* CHECK dout0_19 vdout0_19ck194 = 1.8 time = 1950
* CHECK dout0_20 vdout0_20ck194 = 1.8 time = 1950
* CHECK dout0_21 vdout0_21ck194 = 0 time = 1950
* CHECK dout0_22 vdout0_22ck194 = 1.8 time = 1950
* CHECK dout0_23 vdout0_23ck194 = 1.8 time = 1950
* CHECK dout0_24 vdout0_24ck194 = 0 time = 1950
* CHECK dout0_25 vdout0_25ck194 = 0 time = 1950
* CHECK dout0_26 vdout0_26ck194 = 0 time = 1950
* CHECK dout0_27 vdout0_27ck194 = 0 time = 1950
* CHECK dout0_28 vdout0_28ck194 = 1.8 time = 1950
* CHECK dout0_29 vdout0_29ck194 = 0 time = 1950
* CHECK dout0_30 vdout0_30ck194 = 1.8 time = 1950
* CHECK dout0_31 vdout0_31ck194 = 1.8 time = 1950
* CHECK dout0_0 vdout0_0ck195 = 0 time = 1960
* CHECK dout0_1 vdout0_1ck195 = 1.8 time = 1960
* CHECK dout0_2 vdout0_2ck195 = 0 time = 1960
* CHECK dout0_3 vdout0_3ck195 = 1.8 time = 1960
* CHECK dout0_4 vdout0_4ck195 = 1.8 time = 1960
* CHECK dout0_5 vdout0_5ck195 = 1.8 time = 1960
* CHECK dout0_6 vdout0_6ck195 = 0 time = 1960
* CHECK dout0_7 vdout0_7ck195 = 0 time = 1960
* CHECK dout0_8 vdout0_8ck195 = 1.8 time = 1960
* CHECK dout0_9 vdout0_9ck195 = 1.8 time = 1960
* CHECK dout0_10 vdout0_10ck195 = 1.8 time = 1960
* CHECK dout0_11 vdout0_11ck195 = 1.8 time = 1960
* CHECK dout0_12 vdout0_12ck195 = 0 time = 1960
* CHECK dout0_13 vdout0_13ck195 = 0 time = 1960
* CHECK dout0_14 vdout0_14ck195 = 0 time = 1960
* CHECK dout0_15 vdout0_15ck195 = 1.8 time = 1960
* CHECK dout0_16 vdout0_16ck195 = 0 time = 1960
* CHECK dout0_17 vdout0_17ck195 = 1.8 time = 1960
* CHECK dout0_18 vdout0_18ck195 = 0 time = 1960
* CHECK dout0_19 vdout0_19ck195 = 0 time = 1960
* CHECK dout0_20 vdout0_20ck195 = 0 time = 1960
* CHECK dout0_21 vdout0_21ck195 = 0 time = 1960
* CHECK dout0_22 vdout0_22ck195 = 1.8 time = 1960
* CHECK dout0_23 vdout0_23ck195 = 1.8 time = 1960
* CHECK dout0_24 vdout0_24ck195 = 1.8 time = 1960
* CHECK dout0_25 vdout0_25ck195 = 0 time = 1960
* CHECK dout0_26 vdout0_26ck195 = 0 time = 1960
* CHECK dout0_27 vdout0_27ck195 = 1.8 time = 1960
* CHECK dout0_28 vdout0_28ck195 = 1.8 time = 1960
* CHECK dout0_29 vdout0_29ck195 = 0 time = 1960
* CHECK dout0_30 vdout0_30ck195 = 0 time = 1960
* CHECK dout0_31 vdout0_31ck195 = 1.8 time = 1960
* CHECK dout1_0 vdout1_0ck196 = 0 time = 1970
* CHECK dout1_1 vdout1_1ck196 = 1.8 time = 1970
* CHECK dout1_2 vdout1_2ck196 = 1.8 time = 1970
* CHECK dout1_3 vdout1_3ck196 = 1.8 time = 1970
* CHECK dout1_4 vdout1_4ck196 = 1.8 time = 1970
* CHECK dout1_5 vdout1_5ck196 = 0 time = 1970
* CHECK dout1_6 vdout1_6ck196 = 1.8 time = 1970
* CHECK dout1_7 vdout1_7ck196 = 1.8 time = 1970
* CHECK dout1_8 vdout1_8ck196 = 1.8 time = 1970
* CHECK dout1_9 vdout1_9ck196 = 0 time = 1970
* CHECK dout1_10 vdout1_10ck196 = 0 time = 1970
* CHECK dout1_11 vdout1_11ck196 = 1.8 time = 1970
* CHECK dout1_12 vdout1_12ck196 = 1.8 time = 1970
* CHECK dout1_13 vdout1_13ck196 = 0 time = 1970
* CHECK dout1_14 vdout1_14ck196 = 0 time = 1970
* CHECK dout1_15 vdout1_15ck196 = 1.8 time = 1970
* CHECK dout1_16 vdout1_16ck196 = 1.8 time = 1970
* CHECK dout1_17 vdout1_17ck196 = 0 time = 1970
* CHECK dout1_18 vdout1_18ck196 = 0 time = 1970
* CHECK dout1_19 vdout1_19ck196 = 1.8 time = 1970
* CHECK dout1_20 vdout1_20ck196 = 1.8 time = 1970
* CHECK dout1_21 vdout1_21ck196 = 1.8 time = 1970
* CHECK dout1_22 vdout1_22ck196 = 1.8 time = 1970
* CHECK dout1_23 vdout1_23ck196 = 0 time = 1970
* CHECK dout1_24 vdout1_24ck196 = 1.8 time = 1970
* CHECK dout1_25 vdout1_25ck196 = 1.8 time = 1970
* CHECK dout1_26 vdout1_26ck196 = 1.8 time = 1970
* CHECK dout1_27 vdout1_27ck196 = 0 time = 1970
* CHECK dout1_28 vdout1_28ck196 = 1.8 time = 1970
* CHECK dout1_29 vdout1_29ck196 = 0 time = 1970
* CHECK dout1_30 vdout1_30ck196 = 0 time = 1970
* CHECK dout1_31 vdout1_31ck196 = 0 time = 1970
* CHECK dout0_0 vdout0_0ck197 = 0 time = 1980
* CHECK dout0_1 vdout0_1ck197 = 1.8 time = 1980
* CHECK dout0_2 vdout0_2ck197 = 1.8 time = 1980
* CHECK dout0_3 vdout0_3ck197 = 1.8 time = 1980
* CHECK dout0_4 vdout0_4ck197 = 0 time = 1980
* CHECK dout0_5 vdout0_5ck197 = 0 time = 1980
* CHECK dout0_6 vdout0_6ck197 = 0 time = 1980
* CHECK dout0_7 vdout0_7ck197 = 1.8 time = 1980
* CHECK dout0_8 vdout0_8ck197 = 0 time = 1980
* CHECK dout0_9 vdout0_9ck197 = 0 time = 1980
* CHECK dout0_10 vdout0_10ck197 = 1.8 time = 1980
* CHECK dout0_11 vdout0_11ck197 = 1.8 time = 1980
* CHECK dout0_12 vdout0_12ck197 = 1.8 time = 1980
* CHECK dout0_13 vdout0_13ck197 = 0 time = 1980
* CHECK dout0_14 vdout0_14ck197 = 1.8 time = 1980
* CHECK dout0_15 vdout0_15ck197 = 1.8 time = 1980
* CHECK dout0_16 vdout0_16ck197 = 1.8 time = 1980
* CHECK dout0_17 vdout0_17ck197 = 0 time = 1980
* CHECK dout0_18 vdout0_18ck197 = 1.8 time = 1980
* CHECK dout0_19 vdout0_19ck197 = 0 time = 1980
* CHECK dout0_20 vdout0_20ck197 = 1.8 time = 1980
* CHECK dout0_21 vdout0_21ck197 = 1.8 time = 1980
* CHECK dout0_22 vdout0_22ck197 = 1.8 time = 1980
* CHECK dout0_23 vdout0_23ck197 = 0 time = 1980
* CHECK dout0_24 vdout0_24ck197 = 0 time = 1980
* CHECK dout0_25 vdout0_25ck197 = 1.8 time = 1980
* CHECK dout0_26 vdout0_26ck197 = 0 time = 1980
* CHECK dout0_27 vdout0_27ck197 = 0 time = 1980
* CHECK dout0_28 vdout0_28ck197 = 1.8 time = 1980
* CHECK dout0_29 vdout0_29ck197 = 1.8 time = 1980
* CHECK dout0_30 vdout0_30ck197 = 1.8 time = 1980
* CHECK dout0_31 vdout0_31ck197 = 0 time = 1980
* CHECK dout1_0 vdout1_0ck198 = 0 time = 1990
* CHECK dout1_1 vdout1_1ck198 = 1.8 time = 1990
* CHECK dout1_2 vdout1_2ck198 = 1.8 time = 1990
* CHECK dout1_3 vdout1_3ck198 = 1.8 time = 1990
* CHECK dout1_4 vdout1_4ck198 = 1.8 time = 1990
* CHECK dout1_5 vdout1_5ck198 = 0 time = 1990
* CHECK dout1_6 vdout1_6ck198 = 1.8 time = 1990
* CHECK dout1_7 vdout1_7ck198 = 1.8 time = 1990
* CHECK dout1_8 vdout1_8ck198 = 1.8 time = 1990
* CHECK dout1_9 vdout1_9ck198 = 0 time = 1990
* CHECK dout1_10 vdout1_10ck198 = 0 time = 1990
* CHECK dout1_11 vdout1_11ck198 = 1.8 time = 1990
* CHECK dout1_12 vdout1_12ck198 = 1.8 time = 1990
* CHECK dout1_13 vdout1_13ck198 = 0 time = 1990
* CHECK dout1_14 vdout1_14ck198 = 0 time = 1990
* CHECK dout1_15 vdout1_15ck198 = 1.8 time = 1990
* CHECK dout1_16 vdout1_16ck198 = 1.8 time = 1990
* CHECK dout1_17 vdout1_17ck198 = 0 time = 1990
* CHECK dout1_18 vdout1_18ck198 = 0 time = 1990
* CHECK dout1_19 vdout1_19ck198 = 1.8 time = 1990
* CHECK dout1_20 vdout1_20ck198 = 1.8 time = 1990
* CHECK dout1_21 vdout1_21ck198 = 1.8 time = 1990
* CHECK dout1_22 vdout1_22ck198 = 1.8 time = 1990
* CHECK dout1_23 vdout1_23ck198 = 0 time = 1990
* CHECK dout1_24 vdout1_24ck198 = 1.8 time = 1990
* CHECK dout1_25 vdout1_25ck198 = 1.8 time = 1990
* CHECK dout1_26 vdout1_26ck198 = 1.8 time = 1990
* CHECK dout1_27 vdout1_27ck198 = 0 time = 1990
* CHECK dout1_28 vdout1_28ck198 = 1.8 time = 1990
* CHECK dout1_29 vdout1_29ck198 = 0 time = 1990
* CHECK dout1_30 vdout1_30ck198 = 0 time = 1990
* CHECK dout1_31 vdout1_31ck198 = 0 time = 1990
* CHECK dout0_0 vdout0_0ck199 = 0 time = 2000
* CHECK dout0_1 vdout0_1ck199 = 0 time = 2000
* CHECK dout0_2 vdout0_2ck199 = 1.8 time = 2000
* CHECK dout0_3 vdout0_3ck199 = 0 time = 2000
* CHECK dout0_4 vdout0_4ck199 = 0 time = 2000
* CHECK dout0_5 vdout0_5ck199 = 0 time = 2000
* CHECK dout0_6 vdout0_6ck199 = 1.8 time = 2000
* CHECK dout0_7 vdout0_7ck199 = 1.8 time = 2000
* CHECK dout0_8 vdout0_8ck199 = 0 time = 2000
* CHECK dout0_9 vdout0_9ck199 = 0 time = 2000
* CHECK dout0_10 vdout0_10ck199 = 0 time = 2000
* CHECK dout0_11 vdout0_11ck199 = 1.8 time = 2000
* CHECK dout0_12 vdout0_12ck199 = 1.8 time = 2000
* CHECK dout0_13 vdout0_13ck199 = 0 time = 2000
* CHECK dout0_14 vdout0_14ck199 = 1.8 time = 2000
* CHECK dout0_15 vdout0_15ck199 = 1.8 time = 2000
* CHECK dout0_16 vdout0_16ck199 = 0 time = 2000
* CHECK dout0_17 vdout0_17ck199 = 1.8 time = 2000
* CHECK dout0_18 vdout0_18ck199 = 0 time = 2000
* CHECK dout0_19 vdout0_19ck199 = 1.8 time = 2000
* CHECK dout0_20 vdout0_20ck199 = 1.8 time = 2000
* CHECK dout0_21 vdout0_21ck199 = 0 time = 2000
* CHECK dout0_22 vdout0_22ck199 = 1.8 time = 2000
* CHECK dout0_23 vdout0_23ck199 = 0 time = 2000
* CHECK dout0_24 vdout0_24ck199 = 0 time = 2000
* CHECK dout0_25 vdout0_25ck199 = 1.8 time = 2000
* CHECK dout0_26 vdout0_26ck199 = 0 time = 2000
* CHECK dout0_27 vdout0_27ck199 = 1.8 time = 2000
* CHECK dout0_28 vdout0_28ck199 = 0 time = 2000
* CHECK dout0_29 vdout0_29ck199 = 0 time = 2000
* CHECK dout0_30 vdout0_30ck199 = 0 time = 2000
* CHECK dout0_31 vdout0_31ck199 = 1.8 time = 2000
* CHECK dout0_0 vdout0_0ck200 = 0 time = 2010
* CHECK dout0_1 vdout0_1ck200 = 1.8 time = 2010
* CHECK dout0_2 vdout0_2ck200 = 1.8 time = 2010
* CHECK dout0_3 vdout0_3ck200 = 1.8 time = 2010
* CHECK dout0_4 vdout0_4ck200 = 0 time = 2010
* CHECK dout0_5 vdout0_5ck200 = 1.8 time = 2010
* CHECK dout0_6 vdout0_6ck200 = 1.8 time = 2010
* CHECK dout0_7 vdout0_7ck200 = 1.8 time = 2010
* CHECK dout0_8 vdout0_8ck200 = 0 time = 2010
* CHECK dout0_9 vdout0_9ck200 = 0 time = 2010
* CHECK dout0_10 vdout0_10ck200 = 1.8 time = 2010
* CHECK dout0_11 vdout0_11ck200 = 1.8 time = 2010
* CHECK dout0_12 vdout0_12ck200 = 0 time = 2010
* CHECK dout0_13 vdout0_13ck200 = 1.8 time = 2010
* CHECK dout0_14 vdout0_14ck200 = 1.8 time = 2010
* CHECK dout0_15 vdout0_15ck200 = 0 time = 2010
* CHECK dout0_16 vdout0_16ck200 = 1.8 time = 2010
* CHECK dout0_17 vdout0_17ck200 = 0 time = 2010
* CHECK dout0_18 vdout0_18ck200 = 1.8 time = 2010
* CHECK dout0_19 vdout0_19ck200 = 0 time = 2010
* CHECK dout0_20 vdout0_20ck200 = 0 time = 2010
* CHECK dout0_21 vdout0_21ck200 = 1.8 time = 2010
* CHECK dout0_22 vdout0_22ck200 = 1.8 time = 2010
* CHECK dout0_23 vdout0_23ck200 = 0 time = 2010
* CHECK dout0_24 vdout0_24ck200 = 1.8 time = 2010
* CHECK dout0_25 vdout0_25ck200 = 0 time = 2010
* CHECK dout0_26 vdout0_26ck200 = 1.8 time = 2010
* CHECK dout0_27 vdout0_27ck200 = 0 time = 2010
* CHECK dout0_28 vdout0_28ck200 = 1.8 time = 2010
* CHECK dout0_29 vdout0_29ck200 = 0 time = 2010
* CHECK dout0_30 vdout0_30ck200 = 0 time = 2010
* CHECK dout0_31 vdout0_31ck200 = 0 time = 2010
* CHECK dout1_0 vdout1_0ck201 = 0 time = 2020
* CHECK dout1_1 vdout1_1ck201 = 1.8 time = 2020
* CHECK dout1_2 vdout1_2ck201 = 0 time = 2020
* CHECK dout1_3 vdout1_3ck201 = 1.8 time = 2020
* CHECK dout1_4 vdout1_4ck201 = 1.8 time = 2020
* CHECK dout1_5 vdout1_5ck201 = 1.8 time = 2020
* CHECK dout1_6 vdout1_6ck201 = 0 time = 2020
* CHECK dout1_7 vdout1_7ck201 = 0 time = 2020
* CHECK dout1_8 vdout1_8ck201 = 1.8 time = 2020
* CHECK dout1_9 vdout1_9ck201 = 1.8 time = 2020
* CHECK dout1_10 vdout1_10ck201 = 1.8 time = 2020
* CHECK dout1_11 vdout1_11ck201 = 1.8 time = 2020
* CHECK dout1_12 vdout1_12ck201 = 0 time = 2020
* CHECK dout1_13 vdout1_13ck201 = 0 time = 2020
* CHECK dout1_14 vdout1_14ck201 = 0 time = 2020
* CHECK dout1_15 vdout1_15ck201 = 1.8 time = 2020
* CHECK dout1_16 vdout1_16ck201 = 0 time = 2020
* CHECK dout1_17 vdout1_17ck201 = 1.8 time = 2020
* CHECK dout1_18 vdout1_18ck201 = 0 time = 2020
* CHECK dout1_19 vdout1_19ck201 = 0 time = 2020
* CHECK dout1_20 vdout1_20ck201 = 0 time = 2020
* CHECK dout1_21 vdout1_21ck201 = 0 time = 2020
* CHECK dout1_22 vdout1_22ck201 = 1.8 time = 2020
* CHECK dout1_23 vdout1_23ck201 = 1.8 time = 2020
* CHECK dout1_24 vdout1_24ck201 = 1.8 time = 2020
* CHECK dout1_25 vdout1_25ck201 = 0 time = 2020
* CHECK dout1_26 vdout1_26ck201 = 0 time = 2020
* CHECK dout1_27 vdout1_27ck201 = 1.8 time = 2020
* CHECK dout1_28 vdout1_28ck201 = 1.8 time = 2020
* CHECK dout1_29 vdout1_29ck201 = 0 time = 2020
* CHECK dout1_30 vdout1_30ck201 = 0 time = 2020
* CHECK dout1_31 vdout1_31ck201 = 1.8 time = 2020
* CHECK dout0_0 vdout0_0ck202 = 1.8 time = 2030
* CHECK dout0_1 vdout0_1ck202 = 0 time = 2030
* CHECK dout0_2 vdout0_2ck202 = 0 time = 2030
* CHECK dout0_3 vdout0_3ck202 = 1.8 time = 2030
* CHECK dout0_4 vdout0_4ck202 = 0 time = 2030
* CHECK dout0_5 vdout0_5ck202 = 0 time = 2030
* CHECK dout0_6 vdout0_6ck202 = 0 time = 2030
* CHECK dout0_7 vdout0_7ck202 = 1.8 time = 2030
* CHECK dout0_8 vdout0_8ck202 = 0 time = 2030
* CHECK dout0_9 vdout0_9ck202 = 1.8 time = 2030
* CHECK dout0_10 vdout0_10ck202 = 0 time = 2030
* CHECK dout0_11 vdout0_11ck202 = 1.8 time = 2030
* CHECK dout0_12 vdout0_12ck202 = 0 time = 2030
* CHECK dout0_13 vdout0_13ck202 = 1.8 time = 2030
* CHECK dout0_14 vdout0_14ck202 = 0 time = 2030
* CHECK dout0_15 vdout0_15ck202 = 0 time = 2030
* CHECK dout0_16 vdout0_16ck202 = 0 time = 2030
* CHECK dout0_17 vdout0_17ck202 = 0 time = 2030
* CHECK dout0_18 vdout0_18ck202 = 1.8 time = 2030
* CHECK dout0_19 vdout0_19ck202 = 1.8 time = 2030
* CHECK dout0_20 vdout0_20ck202 = 0 time = 2030
* CHECK dout0_21 vdout0_21ck202 = 0 time = 2030
* CHECK dout0_22 vdout0_22ck202 = 1.8 time = 2030
* CHECK dout0_23 vdout0_23ck202 = 1.8 time = 2030
* CHECK dout0_24 vdout0_24ck202 = 0 time = 2030
* CHECK dout0_25 vdout0_25ck202 = 1.8 time = 2030
* CHECK dout0_26 vdout0_26ck202 = 1.8 time = 2030
* CHECK dout0_27 vdout0_27ck202 = 1.8 time = 2030
* CHECK dout0_28 vdout0_28ck202 = 1.8 time = 2030
* CHECK dout0_29 vdout0_29ck202 = 1.8 time = 2030
* CHECK dout0_30 vdout0_30ck202 = 0 time = 2030
* CHECK dout0_31 vdout0_31ck202 = 1.8 time = 2030
* CHECK dout1_0 vdout1_0ck202 = 0 time = 2030
* CHECK dout1_1 vdout1_1ck202 = 1.8 time = 2030
* CHECK dout1_2 vdout1_2ck202 = 0 time = 2030
* CHECK dout1_3 vdout1_3ck202 = 1.8 time = 2030
* CHECK dout1_4 vdout1_4ck202 = 0 time = 2030
* CHECK dout1_5 vdout1_5ck202 = 1.8 time = 2030
* CHECK dout1_6 vdout1_6ck202 = 0 time = 2030
* CHECK dout1_7 vdout1_7ck202 = 1.8 time = 2030
* CHECK dout1_8 vdout1_8ck202 = 0 time = 2030
* CHECK dout1_9 vdout1_9ck202 = 1.8 time = 2030
* CHECK dout1_10 vdout1_10ck202 = 0 time = 2030
* CHECK dout1_11 vdout1_11ck202 = 1.8 time = 2030
* CHECK dout1_12 vdout1_12ck202 = 0 time = 2030
* CHECK dout1_13 vdout1_13ck202 = 0 time = 2030
* CHECK dout1_14 vdout1_14ck202 = 1.8 time = 2030
* CHECK dout1_15 vdout1_15ck202 = 0 time = 2030
* CHECK dout1_16 vdout1_16ck202 = 1.8 time = 2030
* CHECK dout1_17 vdout1_17ck202 = 0 time = 2030
* CHECK dout1_18 vdout1_18ck202 = 0 time = 2030
* CHECK dout1_19 vdout1_19ck202 = 1.8 time = 2030
* CHECK dout1_20 vdout1_20ck202 = 0 time = 2030
* CHECK dout1_21 vdout1_21ck202 = 0 time = 2030
* CHECK dout1_22 vdout1_22ck202 = 1.8 time = 2030
* CHECK dout1_23 vdout1_23ck202 = 0 time = 2030
* CHECK dout1_24 vdout1_24ck202 = 1.8 time = 2030
* CHECK dout1_25 vdout1_25ck202 = 1.8 time = 2030
* CHECK dout1_26 vdout1_26ck202 = 1.8 time = 2030
* CHECK dout1_27 vdout1_27ck202 = 1.8 time = 2030
* CHECK dout1_28 vdout1_28ck202 = 0 time = 2030
* CHECK dout1_29 vdout1_29ck202 = 1.8 time = 2030
* CHECK dout1_30 vdout1_30ck202 = 1.8 time = 2030
* CHECK dout1_31 vdout1_31ck202 = 1.8 time = 2030
.include /home/carlos/sram_CNN_TFM/sky130_sram_1rw1r_32x1024_8/functional_meas.sp
.OPTIONS DEVICE TEMP=25
.OPTIONS MEASURE MEASFAIL=1
.OPTIONS LINSOL type=klu
.OPTIONS TIMEINT RELTOL=1e-3 ABSTOL=1e-6 method=gear minorder=2
.TRAN 10p 2060n 0n 10p
* probe is used for hspice/xa, while plot is used in ngspice
*.probe V(*)
*.plot V(*)
.end
