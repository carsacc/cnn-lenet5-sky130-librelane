* chip_spi_tb.cir — Xyce testbench: chip_top_spi SPI write/readback
* Write 0xDEADBEEF to param_memory addr 0, read back via SPI
* Core clock: 15 MHz | SPI clock: 5 MHz | Sim time: 39.3 us
*
* Run: mpirun -np 87 /home/carlos/tools/install/xyce/bin/Xyce chip_spi_tb.cir

* ============================================================
* Models — PDK transistor models (TT corner)
* ============================================================
.LIB "/home/carlos/.ciel/ciel/sky130/versions/e8294524e5f67c533c5d0c3afa0bcc5b2a5fa066/sky130A/libs.tech/ngspice/sky130.lib.spice" tt

* ============================================================
* Standard cell transistor-level subcircuits
* ============================================================
.INCLUDE "/home/carlos/.ciel/ciel/sky130/versions/e8294524e5f67c533c5d0c3afa0bcc5b2a5fa066/sky130A/libs.ref/sky130_fd_sc_hd/spice/sky130_fd_sc_hd.spice"

* ============================================================
* Diode model for antenna cells (sky130_fd_sc_hd__diode_2)
* Simplified from sky130 PDK — the original uses parameterized
* expressions that Xyce cannot resolve. These diodes are reverse-
* biased during normal digital operation; only basic IV and cap
* parameters matter for convergence.
* ============================================================
.MODEL sky130_fd_pr__diode_pw2nd_05v5 D
+ IS=2.75e-15 N=1.2928 RS=981 BV=11.7 IBV=0.00106
+ CJO=1.3459e-15 VJ=0.729 M=0.44 EG=1.05 XTI=2.0

* ============================================================
* SRAM macro transistor-level models (OpenRAM)
* ============================================================
.INCLUDE "sram_2048_trimmed.sp"
.INCLUDE "sram_1024_trimmed.sp"

* ============================================================
* Behavioral pad models
* ============================================================
.INCLUDE "pad_models.spice"

* ============================================================
* Chip netlist (gate-level from Magic extraction, stubs stripped)
* ============================================================
.INCLUDE "chip_netlist.spice"

* ============================================================
* Power Supplies (1.8 V)
* ============================================================
Vvdd vdd 0 1.8
Vgnd gnd 0 0

* ============================================================
* DUT — chip_top_spi
* Ports: pad_clk pad_reset pad_spi_cs_n pad_spi_miso pad_spi_mosi
*        pad_spi_sclk vccd1 vddio vssd1 vssio
*        vccd1_uq0 vccd1_uq1 vccd1_uq9
*        vssd1_uq0 vssd1_uq1 vssd1_uq2
*        vssio_uq0 vddio_uq0
* ============================================================
Xdut pad_clk pad_reset pad_spi_cs_n pad_spi_miso pad_spi_mosi pad_spi_sclk
+ vdd vdd gnd gnd vdd vdd vdd gnd gnd gnd gnd vdd
+ chip_top_spi

* ============================================================
* Core Clock — 15 MHz, 1.8V, starts at t=10ns
* ============================================================
Vclk pad_clk 0 PULSE(0 1.8 10n 1.0n 1.0n 32.34n 66.67n)

* ============================================================
* Reset — active HIGH for 1 us, then released
* ============================================================
Vrst pad_reset 0 PWL(0 1.8 1000n 1.8 1001n 0 39280n 0)

* ============================================================
* SPI CS_N
* ============================================================
Vcsn pad_spi_cs_n 0 PWL(
+ 0.0n 1.8000 1499.0n 1.8000 1500.0n 0.0000 12759.0n 0.0000 12760.0n 1.8000 13759.0n 1.8000
+ 13760.0n 0.0000 25019.0n 0.0000 25020.0n 1.8000 26019.0n 1.8000 26020.0n 0.0000 37279.0n 0.0000
+ 37280.0n 1.8000 39280.0n 1.8000)

* ============================================================
* SPI SCLK
* ============================================================
Vsclk pad_spi_sclk 0 PWL(
+ 0.0n 0.0000 1569.0n 0.0000 1570.0n 1.8000 1669.0n 1.8000 1670.0n 0.0000 1769.0n 0.0000
+ 1770.0n 1.8000 1869.0n 1.8000 1870.0n 0.0000 1969.0n 0.0000 1970.0n 1.8000 2069.0n 1.8000
+ 2070.0n 0.0000 2169.0n 0.0000 2170.0n 1.8000 2269.0n 1.8000 2270.0n 0.0000 2369.0n 0.0000
+ 2370.0n 1.8000 2469.0n 1.8000 2470.0n 0.0000 2569.0n 0.0000 2570.0n 1.8000 2669.0n 1.8000
+ 2670.0n 0.0000 2769.0n 0.0000 2770.0n 1.8000 2869.0n 1.8000 2870.0n 0.0000 2969.0n 0.0000
+ 2970.0n 1.8000 3069.0n 1.8000 3070.0n 0.0000 3169.0n 0.0000 3170.0n 1.8000 3269.0n 1.8000
+ 3270.0n 0.0000 3369.0n 0.0000 3370.0n 1.8000 3469.0n 1.8000 3470.0n 0.0000 3569.0n 0.0000
+ 3570.0n 1.8000 3669.0n 1.8000 3670.0n 0.0000 3769.0n 0.0000 3770.0n 1.8000 3869.0n 1.8000
+ 3870.0n 0.0000 3969.0n 0.0000 3970.0n 1.8000 4069.0n 1.8000 4070.0n 0.0000 4169.0n 0.0000
+ 4170.0n 1.8000 4269.0n 1.8000 4270.0n 0.0000 4369.0n 0.0000 4370.0n 1.8000 4469.0n 1.8000
+ 4470.0n 0.0000 4569.0n 0.0000 4570.0n 1.8000 4669.0n 1.8000 4670.0n 0.0000 4769.0n 0.0000
+ 4770.0n 1.8000 4869.0n 1.8000 4870.0n 0.0000 4969.0n 0.0000 4970.0n 1.8000 5069.0n 1.8000
+ 5070.0n 0.0000 5169.0n 0.0000 5170.0n 1.8000 5269.0n 1.8000 5270.0n 0.0000 5369.0n 0.0000
+ 5370.0n 1.8000 5469.0n 1.8000 5470.0n 0.0000 5569.0n 0.0000 5570.0n 1.8000 5669.0n 1.8000
+ 5670.0n 0.0000 5769.0n 0.0000 5770.0n 1.8000 5869.0n 1.8000 5870.0n 0.0000 5969.0n 0.0000
+ 5970.0n 1.8000 6069.0n 1.8000 6070.0n 0.0000 6169.0n 0.0000 6170.0n 1.8000 6269.0n 1.8000
+ 6270.0n 0.0000 6369.0n 0.0000 6370.0n 1.8000 6469.0n 1.8000 6470.0n 0.0000 6569.0n 0.0000
+ 6570.0n 1.8000 6669.0n 1.8000 6670.0n 0.0000 6769.0n 0.0000 6770.0n 1.8000 6869.0n 1.8000
+ 6870.0n 0.0000 6969.0n 0.0000 6970.0n 1.8000 7069.0n 1.8000 7070.0n 0.0000 7169.0n 0.0000
+ 7170.0n 1.8000 7269.0n 1.8000 7270.0n 0.0000 7369.0n 0.0000 7370.0n 1.8000 7469.0n 1.8000
+ 7470.0n 0.0000 7569.0n 0.0000 7570.0n 1.8000 7669.0n 1.8000 7670.0n 0.0000 7769.0n 0.0000
+ 7770.0n 1.8000 7869.0n 1.8000 7870.0n 0.0000 7969.0n 0.0000 7970.0n 1.8000 8069.0n 1.8000
+ 8070.0n 0.0000 8169.0n 0.0000 8170.0n 1.8000 8269.0n 1.8000 8270.0n 0.0000 8369.0n 0.0000
+ 8370.0n 1.8000 8469.0n 1.8000 8470.0n 0.0000 8569.0n 0.0000 8570.0n 1.8000 8669.0n 1.8000
+ 8670.0n 0.0000 8769.0n 0.0000 8770.0n 1.8000 8869.0n 1.8000 8870.0n 0.0000 8969.0n 0.0000
+ 8970.0n 1.8000 9069.0n 1.8000 9070.0n 0.0000 9169.0n 0.0000 9170.0n 1.8000 9269.0n 1.8000
+ 9270.0n 0.0000 9369.0n 0.0000 9370.0n 1.8000 9469.0n 1.8000 9470.0n 0.0000 9569.0n 0.0000
+ 9570.0n 1.8000 9669.0n 1.8000 9670.0n 0.0000 9769.0n 0.0000 9770.0n 1.8000 9869.0n 1.8000
+ 9870.0n 0.0000 9969.0n 0.0000 9970.0n 1.8000 10069.0n 1.8000 10070.0n 0.0000 10169.0n 0.0000
+ 10170.0n 1.8000 10269.0n 1.8000 10270.0n 0.0000 10369.0n 0.0000 10370.0n 1.8000 10469.0n 1.8000
+ 10470.0n 0.0000 10569.0n 0.0000 10570.0n 1.8000 10669.0n 1.8000 10670.0n 0.0000 10769.0n 0.0000
+ 10770.0n 1.8000 10869.0n 1.8000 10870.0n 0.0000 10969.0n 0.0000 10970.0n 1.8000 11069.0n 1.8000
+ 11070.0n 0.0000 11169.0n 0.0000 11170.0n 1.8000 11269.0n 1.8000 11270.0n 0.0000 11369.0n 0.0000
+ 11370.0n 1.8000 11469.0n 1.8000 11470.0n 0.0000 11569.0n 0.0000 11570.0n 1.8000 11669.0n 1.8000
+ 11670.0n 0.0000 11769.0n 0.0000 11770.0n 1.8000 11869.0n 1.8000 11870.0n 0.0000 11969.0n 0.0000
+ 11970.0n 1.8000 12069.0n 1.8000 12070.0n 0.0000 12169.0n 0.0000 12170.0n 1.8000 12269.0n 1.8000
+ 12270.0n 0.0000 12369.0n 0.0000 12370.0n 1.8000 12469.0n 1.8000 12470.0n 0.0000 12569.0n 0.0000
+ 12570.0n 1.8000 12669.0n 1.8000 12670.0n 0.0000 13829.0n 0.0000 13830.0n 1.8000 13929.0n 1.8000
+ 13930.0n 0.0000 14029.0n 0.0000 14030.0n 1.8000 14129.0n 1.8000 14130.0n 0.0000 14229.0n 0.0000
+ 14230.0n 1.8000 14329.0n 1.8000 14330.0n 0.0000 14429.0n 0.0000 14430.0n 1.8000 14529.0n 1.8000
+ 14530.0n 0.0000 14629.0n 0.0000 14630.0n 1.8000 14729.0n 1.8000 14730.0n 0.0000 14829.0n 0.0000
+ 14830.0n 1.8000 14929.0n 1.8000 14930.0n 0.0000 15029.0n 0.0000 15030.0n 1.8000 15129.0n 1.8000
+ 15130.0n 0.0000 15229.0n 0.0000 15230.0n 1.8000 15329.0n 1.8000 15330.0n 0.0000 15429.0n 0.0000
+ 15430.0n 1.8000 15529.0n 1.8000 15530.0n 0.0000 15629.0n 0.0000 15630.0n 1.8000 15729.0n 1.8000
+ 15730.0n 0.0000 15829.0n 0.0000 15830.0n 1.8000 15929.0n 1.8000 15930.0n 0.0000 16029.0n 0.0000
+ 16030.0n 1.8000 16129.0n 1.8000 16130.0n 0.0000 16229.0n 0.0000 16230.0n 1.8000 16329.0n 1.8000
+ 16330.0n 0.0000 16429.0n 0.0000 16430.0n 1.8000 16529.0n 1.8000 16530.0n 0.0000 16629.0n 0.0000
+ 16630.0n 1.8000 16729.0n 1.8000 16730.0n 0.0000 16829.0n 0.0000 16830.0n 1.8000 16929.0n 1.8000
+ 16930.0n 0.0000 17029.0n 0.0000 17030.0n 1.8000 17129.0n 1.8000 17130.0n 0.0000 17229.0n 0.0000
+ 17230.0n 1.8000 17329.0n 1.8000 17330.0n 0.0000 17429.0n 0.0000 17430.0n 1.8000 17529.0n 1.8000
+ 17530.0n 0.0000 17629.0n 0.0000 17630.0n 1.8000 17729.0n 1.8000 17730.0n 0.0000 17829.0n 0.0000
+ 17830.0n 1.8000 17929.0n 1.8000 17930.0n 0.0000 18029.0n 0.0000 18030.0n 1.8000 18129.0n 1.8000
+ 18130.0n 0.0000 18229.0n 0.0000 18230.0n 1.8000 18329.0n 1.8000 18330.0n 0.0000 18429.0n 0.0000
+ 18430.0n 1.8000 18529.0n 1.8000 18530.0n 0.0000 18629.0n 0.0000 18630.0n 1.8000 18729.0n 1.8000
+ 18730.0n 0.0000 18829.0n 0.0000 18830.0n 1.8000 18929.0n 1.8000 18930.0n 0.0000 19029.0n 0.0000
+ 19030.0n 1.8000 19129.0n 1.8000 19130.0n 0.0000 19229.0n 0.0000 19230.0n 1.8000 19329.0n 1.8000
+ 19330.0n 0.0000 19429.0n 0.0000 19430.0n 1.8000 19529.0n 1.8000 19530.0n 0.0000 19629.0n 0.0000
+ 19630.0n 1.8000 19729.0n 1.8000 19730.0n 0.0000 19829.0n 0.0000 19830.0n 1.8000 19929.0n 1.8000
+ 19930.0n 0.0000 20029.0n 0.0000 20030.0n 1.8000 20129.0n 1.8000 20130.0n 0.0000 20229.0n 0.0000
+ 20230.0n 1.8000 20329.0n 1.8000 20330.0n 0.0000 20429.0n 0.0000 20430.0n 1.8000 20529.0n 1.8000
+ 20530.0n 0.0000 20629.0n 0.0000 20630.0n 1.8000 20729.0n 1.8000 20730.0n 0.0000 20829.0n 0.0000
+ 20830.0n 1.8000 20929.0n 1.8000 20930.0n 0.0000 21029.0n 0.0000 21030.0n 1.8000 21129.0n 1.8000
+ 21130.0n 0.0000 21229.0n 0.0000 21230.0n 1.8000 21329.0n 1.8000 21330.0n 0.0000 21429.0n 0.0000
+ 21430.0n 1.8000 21529.0n 1.8000 21530.0n 0.0000 21629.0n 0.0000 21630.0n 1.8000 21729.0n 1.8000
+ 21730.0n 0.0000 21829.0n 0.0000 21830.0n 1.8000 21929.0n 1.8000 21930.0n 0.0000 22029.0n 0.0000
+ 22030.0n 1.8000 22129.0n 1.8000 22130.0n 0.0000 22229.0n 0.0000 22230.0n 1.8000 22329.0n 1.8000
+ 22330.0n 0.0000 22429.0n 0.0000 22430.0n 1.8000 22529.0n 1.8000 22530.0n 0.0000 22629.0n 0.0000
+ 22630.0n 1.8000 22729.0n 1.8000 22730.0n 0.0000 22829.0n 0.0000 22830.0n 1.8000 22929.0n 1.8000
+ 22930.0n 0.0000 23029.0n 0.0000 23030.0n 1.8000 23129.0n 1.8000 23130.0n 0.0000 23229.0n 0.0000
+ 23230.0n 1.8000 23329.0n 1.8000 23330.0n 0.0000 23429.0n 0.0000 23430.0n 1.8000 23529.0n 1.8000
+ 23530.0n 0.0000 23629.0n 0.0000 23630.0n 1.8000 23729.0n 1.8000 23730.0n 0.0000 23829.0n 0.0000
+ 23830.0n 1.8000 23929.0n 1.8000 23930.0n 0.0000 24029.0n 0.0000 24030.0n 1.8000 24129.0n 1.8000
+ 24130.0n 0.0000 24229.0n 0.0000 24230.0n 1.8000 24329.0n 1.8000 24330.0n 0.0000 24429.0n 0.0000
+ 24430.0n 1.8000 24529.0n 1.8000 24530.0n 0.0000 24629.0n 0.0000 24630.0n 1.8000 24729.0n 1.8000
+ 24730.0n 0.0000 24829.0n 0.0000 24830.0n 1.8000 24929.0n 1.8000 24930.0n 0.0000 26089.0n 0.0000
+ 26090.0n 1.8000 26189.0n 1.8000 26190.0n 0.0000 26289.0n 0.0000 26290.0n 1.8000 26389.0n 1.8000
+ 26390.0n 0.0000 26489.0n 0.0000 26490.0n 1.8000 26589.0n 1.8000 26590.0n 0.0000 26689.0n 0.0000
+ 26690.0n 1.8000 26789.0n 1.8000 26790.0n 0.0000 26889.0n 0.0000 26890.0n 1.8000 26989.0n 1.8000
+ 26990.0n 0.0000 27089.0n 0.0000 27090.0n 1.8000 27189.0n 1.8000 27190.0n 0.0000 27289.0n 0.0000
+ 27290.0n 1.8000 27389.0n 1.8000 27390.0n 0.0000 27489.0n 0.0000 27490.0n 1.8000 27589.0n 1.8000
+ 27590.0n 0.0000 27689.0n 0.0000 27690.0n 1.8000 27789.0n 1.8000 27790.0n 0.0000 27889.0n 0.0000
+ 27890.0n 1.8000 27989.0n 1.8000 27990.0n 0.0000 28089.0n 0.0000 28090.0n 1.8000 28189.0n 1.8000
+ 28190.0n 0.0000 28289.0n 0.0000 28290.0n 1.8000 28389.0n 1.8000 28390.0n 0.0000 28489.0n 0.0000
+ 28490.0n 1.8000 28589.0n 1.8000 28590.0n 0.0000 28689.0n 0.0000 28690.0n 1.8000 28789.0n 1.8000
+ 28790.0n 0.0000 28889.0n 0.0000 28890.0n 1.8000 28989.0n 1.8000 28990.0n 0.0000 29089.0n 0.0000
+ 29090.0n 1.8000 29189.0n 1.8000 29190.0n 0.0000 29289.0n 0.0000 29290.0n 1.8000 29389.0n 1.8000
+ 29390.0n 0.0000 29489.0n 0.0000 29490.0n 1.8000 29589.0n 1.8000 29590.0n 0.0000 29689.0n 0.0000
+ 29690.0n 1.8000 29789.0n 1.8000 29790.0n 0.0000 29889.0n 0.0000 29890.0n 1.8000 29989.0n 1.8000
+ 29990.0n 0.0000 30089.0n 0.0000 30090.0n 1.8000 30189.0n 1.8000 30190.0n 0.0000 30289.0n 0.0000
+ 30290.0n 1.8000 30389.0n 1.8000 30390.0n 0.0000 30489.0n 0.0000 30490.0n 1.8000 30589.0n 1.8000
+ 30590.0n 0.0000 30689.0n 0.0000 30690.0n 1.8000 30789.0n 1.8000 30790.0n 0.0000 30889.0n 0.0000
+ 30890.0n 1.8000 30989.0n 1.8000 30990.0n 0.0000 31089.0n 0.0000 31090.0n 1.8000 31189.0n 1.8000
+ 31190.0n 0.0000 31289.0n 0.0000 31290.0n 1.8000 31389.0n 1.8000 31390.0n 0.0000 31489.0n 0.0000
+ 31490.0n 1.8000 31589.0n 1.8000 31590.0n 0.0000 31689.0n 0.0000 31690.0n 1.8000 31789.0n 1.8000
+ 31790.0n 0.0000 31889.0n 0.0000 31890.0n 1.8000 31989.0n 1.8000 31990.0n 0.0000 32089.0n 0.0000
+ 32090.0n 1.8000 32189.0n 1.8000 32190.0n 0.0000 32289.0n 0.0000 32290.0n 1.8000 32389.0n 1.8000
+ 32390.0n 0.0000 32489.0n 0.0000 32490.0n 1.8000 32589.0n 1.8000 32590.0n 0.0000 32689.0n 0.0000
+ 32690.0n 1.8000 32789.0n 1.8000 32790.0n 0.0000 32889.0n 0.0000 32890.0n 1.8000 32989.0n 1.8000
+ 32990.0n 0.0000 33089.0n 0.0000 33090.0n 1.8000 33189.0n 1.8000 33190.0n 0.0000 33289.0n 0.0000
+ 33290.0n 1.8000 33389.0n 1.8000 33390.0n 0.0000 33489.0n 0.0000 33490.0n 1.8000 33589.0n 1.8000
+ 33590.0n 0.0000 33689.0n 0.0000 33690.0n 1.8000 33789.0n 1.8000 33790.0n 0.0000 33889.0n 0.0000
+ 33890.0n 1.8000 33989.0n 1.8000 33990.0n 0.0000 34089.0n 0.0000 34090.0n 1.8000 34189.0n 1.8000
+ 34190.0n 0.0000 34289.0n 0.0000 34290.0n 1.8000 34389.0n 1.8000 34390.0n 0.0000 34489.0n 0.0000
+ 34490.0n 1.8000 34589.0n 1.8000 34590.0n 0.0000 34689.0n 0.0000 34690.0n 1.8000 34789.0n 1.8000
+ 34790.0n 0.0000 34889.0n 0.0000 34890.0n 1.8000 34989.0n 1.8000 34990.0n 0.0000 35089.0n 0.0000
+ 35090.0n 1.8000 35189.0n 1.8000 35190.0n 0.0000 35289.0n 0.0000 35290.0n 1.8000 35389.0n 1.8000
+ 35390.0n 0.0000 35489.0n 0.0000 35490.0n 1.8000 35589.0n 1.8000 35590.0n 0.0000 35689.0n 0.0000
+ 35690.0n 1.8000 35789.0n 1.8000 35790.0n 0.0000 35889.0n 0.0000 35890.0n 1.8000 35989.0n 1.8000
+ 35990.0n 0.0000 36089.0n 0.0000 36090.0n 1.8000 36189.0n 1.8000 36190.0n 0.0000 36289.0n 0.0000
+ 36290.0n 1.8000 36389.0n 1.8000 36390.0n 0.0000 36489.0n 0.0000 36490.0n 1.8000 36589.0n 1.8000
+ 36590.0n 0.0000 36689.0n 0.0000 36690.0n 1.8000 36789.0n 1.8000 36790.0n 0.0000 36889.0n 0.0000
+ 36890.0n 1.8000 36989.0n 1.8000 36990.0n 0.0000 37089.0n 0.0000 37090.0n 1.8000 37189.0n 1.8000
+ 37190.0n 0.0000 39280.0n 0.0000)

* ============================================================
* SPI MOSI
* ============================================================
Vmosi pad_spi_mosi 0 PWL(
+ 0.0n 0.0000 6329.0n 0.0000 6330.0n 1.8000 6729.0n 1.8000 6730.0n 0.0000 6929.0n 0.0000
+ 6930.0n 1.8000 7729.0n 1.8000 7730.0n 0.0000 7929.0n 0.0000 7930.0n 1.8000 8129.0n 1.8000
+ 8130.0n 0.0000 8329.0n 0.0000 8330.0n 1.8000 8529.0n 1.8000 8530.0n 0.0000 8729.0n 0.0000
+ 8730.0n 1.8000 9129.0n 1.8000 9130.0n 0.0000 9329.0n 0.0000 9330.0n 1.8000 9729.0n 1.8000
+ 9730.0n 0.0000 9929.0n 0.0000 9930.0n 1.8000 10929.0n 1.8000 10930.0n 0.0000 11129.0n 0.0000
+ 11130.0n 1.8000 11729.0n 1.8000 11730.0n 0.0000 11929.0n 0.0000 11930.0n 1.8000 13989.0n 1.8000
+ 13990.0n 0.0000 26049.0n 0.0000 26050.0n 1.8000 26249.0n 1.8000 26250.0n 0.0000 39280.0n 0.0000)

* ============================================================
* MISO load (output pad drives this)
* ============================================================
Cmiso pad_spi_miso 0 1p

* ============================================================
* Simulation Control
* ============================================================
.TRAN 50p 39280n

* Solver options for large digital circuit
.OPTIONS TIMEINT METHOD=GEAR ERROPTION=1
.OPTIONS NONLIN MAXSTEP=200 SEARCHMETHOD=2
.OPTIONS DEVICE VOLTLIM=0

* ============================================================
* Output — CSV with SPI signals
* ============================================================
.PRINT TRAN V(pad_clk) V(pad_reset) V(pad_spi_cs_n) V(pad_spi_sclk) V(pad_spi_mosi) V(pad_spi_miso)

.END
